* NGSPICE file created from tcam_top.ext - technology: sky130A

* Black-box entry subcircuit for sky130_fd_sc_hd__tapvpwrvgnd_1 abstract view
.subckt sky130_fd_sc_hd__tapvpwrvgnd_1 VGND VPWR
.ends

* Black-box entry subcircuit for sky130_fd_sc_hd__fill_1 abstract view
.subckt sky130_fd_sc_hd__fill_1 VGND VNB VPB VPWR
.ends

* Black-box entry subcircuit for sky130_fd_sc_hd__decap_6 abstract view
.subckt sky130_fd_sc_hd__decap_6 VGND VNB VPB VPWR
.ends

* Black-box entry subcircuit for sky130_fd_sc_hd__edfxtp_1 abstract view
.subckt sky130_fd_sc_hd__edfxtp_1 CLK D DE VGND VNB VPB VPWR Q
.ends

* Black-box entry subcircuit for sky130_fd_sc_hd__nand2_1 abstract view
.subckt sky130_fd_sc_hd__nand2_1 A B VGND VNB VPB VPWR Y
.ends

* Black-box entry subcircuit for sky130_fd_sc_hd__dfxtp_1 abstract view
.subckt sky130_fd_sc_hd__dfxtp_1 CLK D VGND VNB VPB VPWR Q
.ends

* Black-box entry subcircuit for sky130_fd_sc_hd__clkdlybuf4s50_1 abstract view
.subckt sky130_fd_sc_hd__clkdlybuf4s50_1 A VGND VNB VPB VPWR X
.ends

* Black-box entry subcircuit for sky130_fd_sc_hd__decap_8 abstract view
.subckt sky130_fd_sc_hd__decap_8 VGND VNB VPB VPWR
.ends

* Black-box entry subcircuit for sky130_fd_sc_hd__fill_2 abstract view
.subckt sky130_fd_sc_hd__fill_2 VGND VNB VPB VPWR
.ends

* Black-box entry subcircuit for sky130_fd_sc_hd__nand2_4 abstract view
.subckt sky130_fd_sc_hd__nand2_4 A B VGND VNB VPB VPWR Y
.ends

* Black-box entry subcircuit for sky130_fd_sc_hd__nor3b_1 abstract view
.subckt sky130_fd_sc_hd__nor3b_1 A B C_N VGND VNB VPB VPWR Y
.ends

* Black-box entry subcircuit for sky130_fd_sc_hd__decap_4 abstract view
.subckt sky130_fd_sc_hd__decap_4 VGND VNB VPB VPWR
.ends

* Black-box entry subcircuit for sky130_fd_sc_hd__decap_12 abstract view
.subckt sky130_fd_sc_hd__decap_12 VGND VNB VPB VPWR
.ends

* Black-box entry subcircuit for sky130_fd_sc_hd__nand4_1 abstract view
.subckt sky130_fd_sc_hd__nand4_1 A B C D VGND VNB VPB VPWR Y
.ends

* Black-box entry subcircuit for sky130_fd_sc_hd__nor2_1 abstract view
.subckt sky130_fd_sc_hd__nor2_1 A B VGND VNB VPB VPWR Y
.ends

* Black-box entry subcircuit for sky130_fd_sc_hd__a211oi_2 abstract view
.subckt sky130_fd_sc_hd__a211oi_2 A1 A2 B1 C1 VGND VNB VPB VPWR Y
.ends

* Black-box entry subcircuit for sky130_fd_sc_hd__a22o_1 abstract view
.subckt sky130_fd_sc_hd__a22o_1 A1 A2 B1 B2 VGND VNB VPB VPWR X
.ends

* Black-box entry subcircuit for sky130_fd_sc_hd__a21oi_1 abstract view
.subckt sky130_fd_sc_hd__a21oi_1 A1 A2 B1 VGND VNB VPB VPWR Y
.ends

* Black-box entry subcircuit for sky130_fd_sc_hd__decap_3 abstract view
.subckt sky130_fd_sc_hd__decap_3 VGND VNB VPB VPWR
.ends

* Black-box entry subcircuit for sky130_fd_sc_hd__o21ai_0 abstract view
.subckt sky130_fd_sc_hd__o21ai_0 A1 A2 B1 VGND VNB VPB VPWR Y
.ends

* Black-box entry subcircuit for sky130_fd_sc_hd__inv_2 abstract view
.subckt sky130_fd_sc_hd__inv_2 A VGND VNB VPB VPWR Y
.ends

* Black-box entry subcircuit for sky130_fd_sc_hd__buf_6 abstract view
.subckt sky130_fd_sc_hd__buf_6 A VGND VNB VPB VPWR X
.ends

* Black-box entry subcircuit for sky130_fd_sc_hd__inv_1 abstract view
.subckt sky130_fd_sc_hd__inv_1 A VGND VNB VPB VPWR Y
.ends

* Black-box entry subcircuit for sky130_fd_sc_hd__buf_4 abstract view
.subckt sky130_fd_sc_hd__buf_4 A VGND VNB VPB VPWR X
.ends

* Black-box entry subcircuit for sky130_fd_sc_hd__buf_2 abstract view
.subckt sky130_fd_sc_hd__buf_2 A VGND VNB VPB VPWR X
.ends

* Black-box entry subcircuit for sky130_fd_sc_hd__nor2_4 abstract view
.subckt sky130_fd_sc_hd__nor2_4 A B VGND VNB VPB VPWR Y
.ends

* Black-box entry subcircuit for sky130_fd_sc_hd__o21ai_1 abstract view
.subckt sky130_fd_sc_hd__o21ai_1 A1 A2 B1 VGND VNB VPB VPWR Y
.ends

* Black-box entry subcircuit for sky130_fd_sc_hd__nor3_1 abstract view
.subckt sky130_fd_sc_hd__nor3_1 A B C VGND VNB VPB VPWR Y
.ends

* Black-box entry subcircuit for sky130_fd_sc_hd__o21ba_2 abstract view
.subckt sky130_fd_sc_hd__o21ba_2 A1 A2 B1_N VGND VNB VPB VPWR X
.ends

* Black-box entry subcircuit for sky130_fd_sc_hd__nor2_2 abstract view
.subckt sky130_fd_sc_hd__nor2_2 A B VGND VNB VPB VPWR Y
.ends

* Black-box entry subcircuit for sky130_fd_sc_hd__a221oi_2 abstract view
.subckt sky130_fd_sc_hd__a221oi_2 A1 A2 B1 B2 C1 VGND VNB VPB VPWR Y
.ends

* Black-box entry subcircuit for sky130_fd_sc_hd__clkbuf_16 abstract view
.subckt sky130_fd_sc_hd__clkbuf_16 A VGND VNB VPB VPWR X
.ends

* Black-box entry subcircuit for sky130_fd_sc_hd__nand2_2 abstract view
.subckt sky130_fd_sc_hd__nand2_2 A B VGND VNB VPB VPWR Y
.ends

* Black-box entry subcircuit for sky130_fd_sc_hd__a21oi_4 abstract view
.subckt sky130_fd_sc_hd__a21oi_4 A1 A2 B1 VGND VNB VPB VPWR Y
.ends

* Black-box entry subcircuit for sky130_fd_sc_hd__nor4_4 abstract view
.subckt sky130_fd_sc_hd__nor4_4 A B C D VGND VNB VPB VPWR Y
.ends

* Black-box entry subcircuit for sky130_fd_sc_hd__dlygate4sd3_1 abstract view
.subckt sky130_fd_sc_hd__dlygate4sd3_1 A VGND VNB VPB VPWR X
.ends

* Black-box entry subcircuit for sky130_fd_sc_hd__nand4_2 abstract view
.subckt sky130_fd_sc_hd__nand4_2 A B C D VGND VNB VPB VPWR Y
.ends

* Black-box entry subcircuit for sky130_fd_sc_hd__clkbuf_8 abstract view
.subckt sky130_fd_sc_hd__clkbuf_8 A VGND VNB VPB VPWR X
.ends

* Black-box entry subcircuit for sky130_fd_sc_hd__nand3_1 abstract view
.subckt sky130_fd_sc_hd__nand3_1 A B C VGND VNB VPB VPWR Y
.ends

* Black-box entry subcircuit for sky130_fd_sc_hd__a211oi_1 abstract view
.subckt sky130_fd_sc_hd__a211oi_1 A1 A2 B1 C1 VGND VNB VPB VPWR Y
.ends

* Black-box entry subcircuit for sky130_fd_sc_hd__buf_1 abstract view
.subckt sky130_fd_sc_hd__buf_1 A VGND VNB VPB VPWR X
.ends

* Black-box entry subcircuit for sky130_fd_sc_hd__clkbuf_2 abstract view
.subckt sky130_fd_sc_hd__clkbuf_2 A VGND VNB VPB VPWR X
.ends

* Black-box entry subcircuit for sky130_fd_sc_hd__inv_12 abstract view
.subckt sky130_fd_sc_hd__inv_12 A VGND VNB VPB VPWR Y
.ends

* Black-box entry subcircuit for sky130_fd_sc_hd__bufinv_16 abstract view
.subckt sky130_fd_sc_hd__bufinv_16 A VGND VNB VPB VPWR Y
.ends

* Black-box entry subcircuit for sky130_fd_sc_hd__clkbuf_1 abstract view
.subckt sky130_fd_sc_hd__clkbuf_1 A VGND VNB VPB VPWR X
.ends

* Black-box entry subcircuit for sky130_fd_sc_hd__o22ai_1 abstract view
.subckt sky130_fd_sc_hd__o22ai_1 A1 A2 B1 B2 VGND VNB VPB VPWR Y
.ends

* Black-box entry subcircuit for sky130_fd_sc_hd__clkinv_2 abstract view
.subckt sky130_fd_sc_hd__clkinv_2 A VGND VNB VPB VPWR Y
.ends

* Black-box entry subcircuit for sky130_fd_sc_hd__bufinv_8 abstract view
.subckt sky130_fd_sc_hd__bufinv_8 A VGND VNB VPB VPWR Y
.ends

* Black-box entry subcircuit for sky130_fd_sc_hd__inv_8 abstract view
.subckt sky130_fd_sc_hd__inv_8 A VGND VNB VPB VPWR Y
.ends

* Black-box entry subcircuit for sky130_fd_sc_hd__o211a_1 abstract view
.subckt sky130_fd_sc_hd__o211a_1 A1 A2 B1 C1 VGND VNB VPB VPWR X
.ends

* Black-box entry subcircuit for sky130_fd_sc_hd__a22oi_1 abstract view
.subckt sky130_fd_sc_hd__a22oi_1 A1 A2 B1 B2 VGND VNB VPB VPWR Y
.ends

* Black-box entry subcircuit for sky130_fd_sc_hd__and2_1 abstract view
.subckt sky130_fd_sc_hd__and2_1 A B VGND VNB VPB VPWR X
.ends

* Black-box entry subcircuit for sky130_fd_sc_hd__buf_8 abstract view
.subckt sky130_fd_sc_hd__buf_8 A VGND VNB VPB VPWR X
.ends

* Black-box entry subcircuit for sky130_fd_sc_hd__a21oi_2 abstract view
.subckt sky130_fd_sc_hd__a21oi_2 A1 A2 B1 VGND VNB VPB VPWR Y
.ends

* Black-box entry subcircuit for sky130_fd_sc_hd__a221oi_1 abstract view
.subckt sky130_fd_sc_hd__a221oi_1 A1 A2 B1 B2 C1 VGND VNB VPB VPWR Y
.ends

* Black-box entry subcircuit for sky130_fd_sc_hd__inv_6 abstract view
.subckt sky130_fd_sc_hd__inv_6 A VGND VNB VPB VPWR Y
.ends

* Black-box entry subcircuit for sky130_fd_sc_hd__o21bai_1 abstract view
.subckt sky130_fd_sc_hd__o21bai_1 A1 A2 B1_N VGND VNB VPB VPWR Y
.ends

* Black-box entry subcircuit for sky130_fd_sc_hd__o21a_1 abstract view
.subckt sky130_fd_sc_hd__o21a_1 A1 A2 B1 VGND VNB VPB VPWR X
.ends

* Black-box entry subcircuit for sky130_fd_sc_hd__inv_4 abstract view
.subckt sky130_fd_sc_hd__inv_4 A VGND VNB VPB VPWR Y
.ends

* Black-box entry subcircuit for sky130_fd_sc_hd__o2111ai_1 abstract view
.subckt sky130_fd_sc_hd__o2111ai_1 A1 A2 B1 C1 D1 VGND VNB VPB VPWR Y
.ends

* Black-box entry subcircuit for sky130_fd_sc_hd__and3b_1 abstract view
.subckt sky130_fd_sc_hd__and3b_1 A_N B C VGND VNB VPB VPWR X
.ends

* Black-box entry subcircuit for sky130_fd_sc_hd__nor3b_2 abstract view
.subckt sky130_fd_sc_hd__nor3b_2 A B C_N VGND VNB VPB VPWR Y
.ends

* Black-box entry subcircuit for sky130_fd_sc_hd__nand3_2 abstract view
.subckt sky130_fd_sc_hd__nand3_2 A B C VGND VNB VPB VPWR Y
.ends

.subckt tcam_top VGND VPWR addr[0] addr[1] addr[2] addr[3] clk data[0] data[1] data[2]
+ data[3] data[4] data[5] match_addr[0] match_addr[1] match_addr[2] match_addr[3]
+ match_valid multi_match op[0] op[1] rst
XTAP_TAPCELL_ROW_9_148 VGND VPWR sky130_fd_sc_hd__tapvpwrvgnd_1
XFILLER_7_7 VGND VGND VPWR VPWR sky130_fd_sc_hd__fill_1
XFILLER_26_85 VGND VGND VPWR VPWR sky130_fd_sc_hd__decap_6
X_1270_ _1459_/CLK _1446_/D _1277_/DE VGND VGND VPWR VPWR _1270_/Q sky130_fd_sc_hd__edfxtp_1
X_0985_ _1106_/A _1279_/Q VGND VGND VPWR VPWR _0989_/A sky130_fd_sc_hd__nand2_1
XTAP_TAPCELL_ROW_14_183 VGND VPWR sky130_fd_sc_hd__tapvpwrvgnd_1
X_1399_ clkload2/A _1415_/D _0650_/B VGND VGND VPWR VPWR _1399_/Q sky130_fd_sc_hd__edfxtp_1
X_1468_ _1468_/CLK _1468_/D VGND VGND VPWR VPWR _1468_/Q sky130_fd_sc_hd__dfxtp_1
Xfanout105 _1199_/B1 VGND VGND VPWR VPWR _1193_/B1 sky130_fd_sc_hd__clkdlybuf4s50_1
XTAP_TAPCELL_ROW_6_129 VGND VPWR sky130_fd_sc_hd__tapvpwrvgnd_1
XFILLER_27_225 VGND VGND VPWR VPWR sky130_fd_sc_hd__decap_6
XFILLER_6_107 VGND VGND VPWR VPWR sky130_fd_sc_hd__fill_1
XFILLER_2_368 VGND VGND VPWR VPWR sky130_fd_sc_hd__decap_8
XFILLER_37_40 VGND VGND VPWR VPWR sky130_fd_sc_hd__fill_1
X_0770_ _1080_/A _1328_/Q VGND VGND VPWR VPWR _0772_/C sky130_fd_sc_hd__nand2_1
X_1322_ clkload8/A _1450_/D _1327_/DE VGND VGND VPWR VPWR _1322_/Q sky130_fd_sc_hd__edfxtp_1
X_1253_ _1468_/CLK _1445_/D _1259_/DE VGND VGND VPWR VPWR _1253_/Q sky130_fd_sc_hd__edfxtp_1
XFILLER_5_184 VGND VGND VPWR VPWR sky130_fd_sc_hd__fill_2
X_1184_ _1191_/A _1412_/D VGND VGND VPWR VPWR _1184_/Y sky130_fd_sc_hd__nand2_1
XFILLER_32_261 VGND VGND VPWR VPWR sky130_fd_sc_hd__decap_8
X_0968_ _0968_/A _0968_/B VGND VGND VPWR VPWR _1157_/B sky130_fd_sc_hd__nand2_4
X_0899_ _0899_/A _0899_/B _0897_/Y VGND VGND VPWR VPWR _0900_/B sky130_fd_sc_hd__nor3b_1
XFILLER_15_239 VGND VGND VPWR VPWR sky130_fd_sc_hd__decap_4
XFILLER_23_261 VGND VGND VPWR VPWR sky130_fd_sc_hd__decap_12
XFILLER_38_309 VGND VGND VPWR VPWR sky130_fd_sc_hd__decap_8
XFILLER_0_57 VGND VGND VPWR VPWR sky130_fd_sc_hd__decap_12
X_0822_ _1053_/A _1361_/Q VGND VGND VPWR VPWR _0825_/B sky130_fd_sc_hd__nand2_1
XFILLER_9_44 VGND VGND VPWR VPWR sky130_fd_sc_hd__decap_12
X_0753_ _0902_/A _1418_/Q VGND VGND VPWR VPWR _0755_/B sky130_fd_sc_hd__nand2_1
X_0684_ _0684_/A _0684_/B _0684_/C _0684_/D VGND VGND VPWR VPWR _0685_/D sky130_fd_sc_hd__nand4_1
XFILLER_29_309 VGND VGND VPWR VPWR sky130_fd_sc_hd__decap_12
X_1305_ clkload8/A _1449_/D _0625_/B VGND VGND VPWR VPWR _1305_/Q sky130_fd_sc_hd__edfxtp_1
X_1236_ _1469_/CLK _1444_/D _0613_/A VGND VGND VPWR VPWR _1236_/Q sky130_fd_sc_hd__edfxtp_1
XTAP_TAPCELL_ROW_39_348 VGND VPWR sky130_fd_sc_hd__tapvpwrvgnd_1
X_1167_ input3/X _1167_/B VGND VGND VPWR VPWR _1178_/A sky130_fd_sc_hd__nor2_1
X_1098_ _1043_/B _1076_/X _1193_/B1 _1087_/Y VGND VGND VPWR VPWR _1491_/D sky130_fd_sc_hd__a211oi_2
XTAP_TAPCELL_ROW_30_281 VGND VPWR sky130_fd_sc_hd__tapvpwrvgnd_1
XFILLER_34_74 VGND VGND VPWR VPWR sky130_fd_sc_hd__decap_8
XFILLER_34_85 VGND VGND VPWR VPWR sky130_fd_sc_hd__decap_4
XFILLER_7_235 VGND VGND VPWR VPWR sky130_fd_sc_hd__decap_6
X_1021_ _1080_/A _1296_/Q VGND VGND VPWR VPWR _1023_/C sky130_fd_sc_hd__nand2_1
X_0805_ _1120_/X _1349_/Q _0934_/A _1355_/Q VGND VGND VPWR VPWR _0805_/X sky130_fd_sc_hd__a22o_1
X_0736_ _0908_/A _1398_/Q _0998_/A _1404_/Q VGND VGND VPWR VPWR _0736_/X sky130_fd_sc_hd__a22o_1
X_0667_ _0934_/A _1435_/Q _0666_/Y VGND VGND VPWR VPWR _0668_/A sky130_fd_sc_hd__a21oi_1
X_0598_ _1154_/B _0798_/A VGND VGND VPWR VPWR _0709_/A sky130_fd_sc_hd__nand2_1
X_1219_ clkload5/A _1411_/D _1229_/DE VGND VGND VPWR VPWR _1219_/Q sky130_fd_sc_hd__edfxtp_1
XFILLER_20_32 VGND VGND VPWR VPWR sky130_fd_sc_hd__decap_12
XFILLER_29_85 VGND VGND VPWR VPWR sky130_fd_sc_hd__decap_3
XFILLER_3_271 VGND VGND VPWR VPWR sky130_fd_sc_hd__fill_1
XFILLER_6_89 VGND VGND VPWR VPWR sky130_fd_sc_hd__decap_12
XFILLER_13_3 VGND VGND VPWR VPWR sky130_fd_sc_hd__decap_6
XFILLER_22_304 VGND VGND VPWR VPWR sky130_fd_sc_hd__decap_4
X_1004_ _1083_/A _1286_/Q VGND VGND VPWR VPWR _1005_/D sky130_fd_sc_hd__nand2_1
XFILLER_1_219 VGND VGND VPWR VPWR sky130_fd_sc_hd__fill_2
X_0719_ _1109_/A _0717_/Y _0718_/Y VGND VGND VPWR VPWR _0719_/Y sky130_fd_sc_hd__o21ai_0
XFILLER_13_337 VGND VGND VPWR VPWR sky130_fd_sc_hd__fill_1
XFILLER_31_86 VGND VGND VPWR VPWR sky130_fd_sc_hd__decap_12
XFILLER_0_285 VGND VGND VPWR VPWR sky130_fd_sc_hd__decap_12
XFILLER_8_374 VGND VGND VPWR VPWR sky130_fd_sc_hd__decap_4
XFILLER_39_201 VGND VGND VPWR VPWR sky130_fd_sc_hd__decap_6
X_1484_ clkload3/A _1484_/D VGND VGND VPWR VPWR _1484_/Q sky130_fd_sc_hd__dfxtp_1
XFILLER_10_307 VGND VGND VPWR VPWR sky130_fd_sc_hd__fill_1
XTAP_TAPCELL_ROW_9_149 VGND VPWR sky130_fd_sc_hd__tapvpwrvgnd_1
XFILLER_3_57 VGND VGND VPWR VPWR sky130_fd_sc_hd__decap_4
X_0984_ _0984_/A _0984_/B VGND VGND VPWR VPWR _0990_/A sky130_fd_sc_hd__nand2_1
X_1398_ clkload2/A _1414_/D _0650_/B VGND VGND VPWR VPWR _1398_/Q sky130_fd_sc_hd__edfxtp_1
X_1467_ _1468_/CLK _1467_/D VGND VGND VPWR VPWR _1467_/Q sky130_fd_sc_hd__dfxtp_1
Xfanout106 _0642_/A VGND VGND VPWR VPWR _1199_/B1 sky130_fd_sc_hd__clkdlybuf4s50_1
XFILLER_2_336 VGND VGND VPWR VPWR sky130_fd_sc_hd__fill_2
XFILLER_5_174 VGND VGND VPWR VPWR sky130_fd_sc_hd__fill_1
X_1321_ clkload8/A _1449_/D _1327_/DE VGND VGND VPWR VPWR _1321_/Q sky130_fd_sc_hd__edfxtp_1
X_1252_ _1468_/CLK _1444_/D _1259_/DE VGND VGND VPWR VPWR _1252_/Q sky130_fd_sc_hd__edfxtp_1
XFILLER_17_281 VGND VGND VPWR VPWR sky130_fd_sc_hd__decap_8
X_1183_ _1181_/Y _1182_/Y _0642_/A VGND VGND VPWR VPWR _1483_/D sky130_fd_sc_hd__a21oi_1
XTAP_TAPCELL_ROW_19_210 VGND VPWR sky130_fd_sc_hd__tapvpwrvgnd_1
X_0967_ _0967_/A VGND VGND VPWR VPWR _0968_/B sky130_fd_sc_hd__inv_2
X_0898_ _1092_/A VGND VGND VPWR VPWR _1045_/A sky130_fd_sc_hd__buf_6
XPHY_EDGE_ROW_12_Right_12 VGND VGND VPWR VPWR sky130_fd_sc_hd__decap_3
XTAP_TAPCELL_ROW_2_100 VGND VPWR sky130_fd_sc_hd__tapvpwrvgnd_1
XPHY_EDGE_ROW_21_Right_21 VGND VGND VPWR VPWR sky130_fd_sc_hd__decap_3
XFILLER_15_229 VGND VGND VPWR VPWR sky130_fd_sc_hd__fill_1
XFILLER_23_273 VGND VGND VPWR VPWR sky130_fd_sc_hd__decap_6
XFILLER_23_43 VGND VGND VPWR VPWR sky130_fd_sc_hd__decap_12
XPHY_EDGE_ROW_30_Right_30 VGND VGND VPWR VPWR sky130_fd_sc_hd__decap_3
XFILLER_0_69 VGND VGND VPWR VPWR sky130_fd_sc_hd__decap_12
XFILLER_14_273 VGND VGND VPWR VPWR sky130_fd_sc_hd__fill_1
X_0821_ _0998_/B VGND VGND VPWR VPWR _1131_/B sky130_fd_sc_hd__inv_1
X_0752_ _1099_/A _1411_/Q VGND VGND VPWR VPWR _0755_/A sky130_fd_sc_hd__nand2_1
X_0683_ _0932_/A _1426_/Q VGND VGND VPWR VPWR _0684_/D sky130_fd_sc_hd__nand2_1
X_1304_ clkload8/A _1448_/D _1304_/DE VGND VGND VPWR VPWR _1304_/Q sky130_fd_sc_hd__edfxtp_1
X_1235_ _1459_/CLK _1443_/D _1247_/DE VGND VGND VPWR VPWR _1235_/Q sky130_fd_sc_hd__edfxtp_1
X_1166_ _1164_/Y _1165_/Y _0642_/A VGND VGND VPWR VPWR _1484_/D sky130_fd_sc_hd__a21oi_1
XTAP_TAPCELL_ROW_39_349 VGND VPWR sky130_fd_sc_hd__tapvpwrvgnd_1
XTAP_TAPCELL_ROW_0_90 VGND VPWR sky130_fd_sc_hd__tapvpwrvgnd_1
XFILLER_20_210 VGND VGND VPWR VPWR sky130_fd_sc_hd__fill_1
X_1097_ _1100_/A _1097_/B VGND VGND VPWR VPWR _1102_/A sky130_fd_sc_hd__nor2_1
XTAP_TAPCELL_ROW_30_282 VGND VPWR sky130_fd_sc_hd__tapvpwrvgnd_1
XPHY_EDGE_ROW_8_Left_48 VGND VGND VPWR VPWR sky130_fd_sc_hd__decap_3
XFILLER_28_376 VGND VGND VPWR VPWR sky130_fd_sc_hd__fill_2
XFILLER_7_225 VGND VGND VPWR VPWR sky130_fd_sc_hd__fill_2
Xload_slew42 _1434_/DE VGND VGND VPWR VPWR _1437_/DE sky130_fd_sc_hd__buf_4
X_1020_ input6/X _1043_/B VGND VGND VPWR VPWR _1020_/Y sky130_fd_sc_hd__nor2_1
XFILLER_34_313 VGND VGND VPWR VPWR sky130_fd_sc_hd__fill_1
X_0804_ _0804_/A _0804_/B VGND VGND VPWR VPWR _0807_/C sky130_fd_sc_hd__nor2_1
X_0735_ _1089_/A VGND VGND VPWR VPWR _1070_/B sky130_fd_sc_hd__buf_6
X_0666_ _0666_/A _0666_/B VGND VGND VPWR VPWR _0666_/Y sky130_fd_sc_hd__nand2_1
X_0597_ input3/X input4/X VGND VGND VPWR VPWR _1042_/A sky130_fd_sc_hd__nand2_1
X_1218_ clkload7/A _1410_/D _1231_/DE VGND VGND VPWR VPWR _1218_/Q sky130_fd_sc_hd__edfxtp_1
X_1149_ _1149_/A _1149_/B VGND VGND VPWR VPWR _1150_/B sky130_fd_sc_hd__nor2_1
XFILLER_19_140 VGND VGND VPWR VPWR sky130_fd_sc_hd__decap_12
X_1003_ _1080_/A _1280_/Q VGND VGND VPWR VPWR _1005_/C sky130_fd_sc_hd__nand2_1
XTAP_TAPCELL_ROW_32_300 VGND VPWR sky130_fd_sc_hd__tapvpwrvgnd_1
X_0718_ _0902_/A _1402_/Q VGND VGND VPWR VPWR _0718_/Y sky130_fd_sc_hd__nand2_1
XPHY_EDGE_ROW_6_Right_6 VGND VGND VPWR VPWR sky130_fd_sc_hd__decap_3
X_0649_ _0649_/A VGND VGND VPWR VPWR _1456_/D sky130_fd_sc_hd__buf_2
XFILLER_13_316 VGND VGND VPWR VPWR sky130_fd_sc_hd__decap_12
XFILLER_15_55 VGND VGND VPWR VPWR sky130_fd_sc_hd__fill_1
XFILLER_15_99 VGND VGND VPWR VPWR sky130_fd_sc_hd__fill_1
XFILLER_0_253 VGND VGND VPWR VPWR sky130_fd_sc_hd__decap_12
XFILLER_31_98 VGND VGND VPWR VPWR sky130_fd_sc_hd__decap_12
XFILLER_0_297 VGND VGND VPWR VPWR sky130_fd_sc_hd__decap_6
XFILLER_16_165 VGND VGND VPWR VPWR sky130_fd_sc_hd__decap_6
XFILLER_31_179 VGND VGND VPWR VPWR sky130_fd_sc_hd__fill_1
X_1483_ _1494_/CLK _1483_/D VGND VGND VPWR VPWR _1483_/Q sky130_fd_sc_hd__dfxtp_1
XPHY_EDGE_ROW_37_Left_77 VGND VGND VPWR VPWR sky130_fd_sc_hd__decap_3
XFILLER_13_102 VGND VGND VPWR VPWR sky130_fd_sc_hd__decap_8
XFILLER_13_113 VGND VGND VPWR VPWR sky130_fd_sc_hd__decap_6
XFILLER_5_367 VGND VGND VPWR VPWR sky130_fd_sc_hd__decap_8
XFILLER_5_356 VGND VGND VPWR VPWR sky130_fd_sc_hd__fill_2
XFILLER_36_205 VGND VGND VPWR VPWR sky130_fd_sc_hd__decap_3
X_0983_ _1046_/A _1272_/Q VGND VGND VPWR VPWR _0984_/B sky130_fd_sc_hd__nand2_1
Xfanout107 _0639_/A VGND VGND VPWR VPWR _0642_/A sky130_fd_sc_hd__clkdlybuf4s50_1
XFILLER_8_194 VGND VGND VPWR VPWR sky130_fd_sc_hd__fill_2
X_1397_ clkload5/A _1413_/D _0650_/B VGND VGND VPWR VPWR _1397_/Q sky130_fd_sc_hd__edfxtp_1
X_1466_ _1466_/CLK _1466_/D VGND VGND VPWR VPWR _1466_/Q sky130_fd_sc_hd__dfxtp_1
XTAP_TAPCELL_ROW_5_120 VGND VPWR sky130_fd_sc_hd__tapvpwrvgnd_1
XFILLER_18_205 VGND VGND VPWR VPWR sky130_fd_sc_hd__fill_2
X_1320_ clkload8/A _1448_/D _1327_/DE VGND VGND VPWR VPWR _1320_/Q sky130_fd_sc_hd__edfxtp_1
X_1251_ _1468_/CLK _1443_/D _1263_/DE VGND VGND VPWR VPWR _1251_/Q sky130_fd_sc_hd__edfxtp_1
X_1182_ _1192_/A _1419_/D VGND VGND VPWR VPWR _1182_/Y sky130_fd_sc_hd__nand2_1
XTAP_TAPCELL_ROW_19_211 VGND VPWR sky130_fd_sc_hd__tapvpwrvgnd_1
XFILLER_17_271 VGND VGND VPWR VPWR sky130_fd_sc_hd__decap_8
X_0966_ _1149_/A _1150_/A VGND VGND VPWR VPWR _0968_/A sky130_fd_sc_hd__nor2_4
X_0897_ _1214_/Q _1106_/A _1215_/Q VGND VGND VPWR VPWR _0897_/Y sky130_fd_sc_hd__o21ai_1
X_1449_ _1456_/CLK _1449_/D _1453_/DE VGND VGND VPWR VPWR _1449_/Q sky130_fd_sc_hd__edfxtp_1
XTAP_TAPCELL_ROW_2_101 VGND VPWR sky130_fd_sc_hd__tapvpwrvgnd_1
XFILLER_23_55 VGND VGND VPWR VPWR sky130_fd_sc_hd__fill_1
XFILLER_23_77 VGND VGND VPWR VPWR sky130_fd_sc_hd__decap_8
XFILLER_3_3 VGND VGND VPWR VPWR sky130_fd_sc_hd__fill_1
XFILLER_0_15 VGND VGND VPWR VPWR sky130_fd_sc_hd__decap_12
XFILLER_0_37 VGND VGND VPWR VPWR sky130_fd_sc_hd__decap_12
XFILLER_14_230 VGND VGND VPWR VPWR sky130_fd_sc_hd__fill_2
X_0820_ input1/X VGND VGND VPWR VPWR _0931_/C sky130_fd_sc_hd__inv_1
X_0751_ _0751_/A _0751_/B VGND VGND VPWR VPWR _0762_/B sky130_fd_sc_hd__nor2_1
XPHY_EDGE_ROW_24_Left_64 VGND VGND VPWR VPWR sky130_fd_sc_hd__decap_3
XFILLER_9_57 VGND VGND VPWR VPWR sky130_fd_sc_hd__decap_12
X_1303_ clkload9/A _1447_/D _0625_/B VGND VGND VPWR VPWR _1303_/Q sky130_fd_sc_hd__edfxtp_1
X_0682_ _1103_/A _1428_/Q VGND VGND VPWR VPWR _0684_/C sky130_fd_sc_hd__nand2_1
XTAP_TAPCELL_ROW_0_91 VGND VPWR sky130_fd_sc_hd__tapvpwrvgnd_1
XTAP_TAPCELL_ROW_0_80 VGND VPWR sky130_fd_sc_hd__tapvpwrvgnd_1
X_1234_ _1469_/CLK _1442_/D _0613_/A VGND VGND VPWR VPWR _1234_/Q sky130_fd_sc_hd__edfxtp_1
X_1165_ _1192_/A _1420_/D VGND VGND VPWR VPWR _1165_/Y sky130_fd_sc_hd__nand2_1
X_1096_ _1243_/Q VGND VGND VPWR VPWR _1097_/B sky130_fd_sc_hd__inv_1
XFILLER_20_299 VGND VGND VPWR VPWR sky130_fd_sc_hd__fill_2
X_0949_ _0949_/A _0949_/B _0949_/C VGND VGND VPWR VPWR _0963_/A sky130_fd_sc_hd__nor3_1
XTAP_TAPCELL_ROW_30_283 VGND VPWR sky130_fd_sc_hd__tapvpwrvgnd_1
XFILLER_28_333 VGND VGND VPWR VPWR sky130_fd_sc_hd__decap_4
XFILLER_18_55 VGND VGND VPWR VPWR sky130_fd_sc_hd__fill_1
XFILLER_11_277 VGND VGND VPWR VPWR sky130_fd_sc_hd__decap_3
XFILLER_19_300 VGND VGND VPWR VPWR sky130_fd_sc_hd__fill_2
XFILLER_19_355 VGND VGND VPWR VPWR sky130_fd_sc_hd__decap_3
XFILLER_19_366 VGND VGND VPWR VPWR sky130_fd_sc_hd__decap_12
X_0803_ _0803_/A _0803_/B _0803_/C _1462_/Q VGND VGND VPWR VPWR _0804_/B sky130_fd_sc_hd__nand4_1
X_0734_ _0734_/A _0734_/B VGND VGND VPWR VPWR _0738_/C sky130_fd_sc_hd__nor2_1
X_0665_ input2/X input1/X _0709_/A VGND VGND VPWR VPWR _0676_/A sky130_fd_sc_hd__nor3_1
X_1217_ clkload6/A _1409_/D _1231_/DE VGND VGND VPWR VPWR _1217_/Q sky130_fd_sc_hd__edfxtp_1
X_1148_ _1148_/A _1148_/B VGND VGND VPWR VPWR _1149_/B sky130_fd_sc_hd__nor2_1
X_1079_ _1079_/A _1239_/Q VGND VGND VPWR VPWR _1081_/A sky130_fd_sc_hd__nand2_1
XFILLER_20_23 VGND VGND VPWR VPWR sky130_fd_sc_hd__decap_4
XFILLER_16_369 VGND VGND VPWR VPWR sky130_fd_sc_hd__decap_8
XFILLER_19_152 VGND VGND VPWR VPWR sky130_fd_sc_hd__decap_12
XFILLER_34_166 VGND VGND VPWR VPWR sky130_fd_sc_hd__decap_12
X_1002_ _1053_/A _1281_/Q VGND VGND VPWR VPWR _1005_/B sky130_fd_sc_hd__nand2_1
XFILLER_22_339 VGND VGND VPWR VPWR sky130_fd_sc_hd__fill_1
X_0717_ _1397_/Q VGND VGND VPWR VPWR _0717_/Y sky130_fd_sc_hd__inv_2
X_0648_ hold121/X _1455_/DE _0651_/A VGND VGND VPWR VPWR _0649_/A sky130_fd_sc_hd__o21ba_2
XFILLER_13_328 VGND VGND VPWR VPWR sky130_fd_sc_hd__decap_8
XPHY_EDGE_ROW_11_Left_51 VGND VGND VPWR VPWR sky130_fd_sc_hd__decap_3
XFILLER_0_265 VGND VGND VPWR VPWR sky130_fd_sc_hd__decap_8
X_1482_ clkload3/A _1482_/D VGND VGND VPWR VPWR _1482_/Q sky130_fd_sc_hd__dfxtp_1
XFILLER_10_309 VGND VGND VPWR VPWR sky130_fd_sc_hd__decap_12
XFILLER_9_129 VGND VGND VPWR VPWR sky130_fd_sc_hd__fill_1
XFILLER_3_48 VGND VGND VPWR VPWR sky130_fd_sc_hd__fill_1
XTAP_TAPCELL_ROW_8_140 VGND VPWR sky130_fd_sc_hd__tapvpwrvgnd_1
X_0982_ _1045_/A _1273_/Q VGND VGND VPWR VPWR _0984_/A sky130_fd_sc_hd__nand2_1
XFILLER_8_184 VGND VGND VPWR VPWR sky130_fd_sc_hd__fill_2
X_1465_ _1466_/CLK _1465_/D VGND VGND VPWR VPWR _1465_/Q sky130_fd_sc_hd__dfxtp_1
Xfanout108 _0651_/A VGND VGND VPWR VPWR _0639_/A sky130_fd_sc_hd__clkdlybuf4s50_1
X_1396_ clkload2/A _1412_/D _0650_/B VGND VGND VPWR VPWR _1396_/Q sky130_fd_sc_hd__edfxtp_1
XFILLER_10_139 VGND VGND VPWR VPWR sky130_fd_sc_hd__fill_1
XTAP_TAPCELL_ROW_5_121 VGND VPWR sky130_fd_sc_hd__tapvpwrvgnd_1
XFILLER_37_65 VGND VGND VPWR VPWR sky130_fd_sc_hd__decap_6
XFILLER_5_110 VGND VGND VPWR VPWR sky130_fd_sc_hd__fill_2
X_1250_ _1468_/CLK _1442_/D _1259_/DE VGND VGND VPWR VPWR _1250_/Q sky130_fd_sc_hd__edfxtp_1
X_1181_ _1191_/A _1413_/D VGND VGND VPWR VPWR _1181_/Y sky130_fd_sc_hd__nand2_1
XTAP_TAPCELL_ROW_19_212 VGND VPWR sky130_fd_sc_hd__tapvpwrvgnd_1
X_0965_ _0998_/B _0943_/X _1199_/B1 _0954_/Y VGND VGND VPWR VPWR _1495_/D sky130_fd_sc_hd__a211oi_2
X_0896_ _1207_/Q _0896_/B VGND VGND VPWR VPWR _0899_/B sky130_fd_sc_hd__nor2_1
X_1448_ _1456_/CLK _1448_/D _1453_/DE VGND VGND VPWR VPWR _1448_/Q sky130_fd_sc_hd__edfxtp_1
XTAP_TAPCELL_ROW_2_102 VGND VPWR sky130_fd_sc_hd__tapvpwrvgnd_1
XFILLER_23_231 VGND VGND VPWR VPWR sky130_fd_sc_hd__fill_1
X_1379_ clkload1/A _1411_/D _1391_/DE VGND VGND VPWR VPWR _1379_/Q sky130_fd_sc_hd__edfxtp_1
XFILLER_0_27 VGND VGND VPWR VPWR sky130_fd_sc_hd__fill_1
XFILLER_0_49 VGND VGND VPWR VPWR sky130_fd_sc_hd__decap_6
XFILLER_9_69 VGND VGND VPWR VPWR sky130_fd_sc_hd__decap_12
Xfanout90 _1479_/Q VGND VGND VPWR VPWR _1447_/D sky130_fd_sc_hd__clkdlybuf4s50_1
X_0750_ _0750_/A _0750_/B _0750_/C _0750_/D VGND VGND VPWR VPWR _0751_/B sky130_fd_sc_hd__nand4_1
X_0681_ _1106_/A _1439_/Q _0680_/Y VGND VGND VPWR VPWR _0684_/B sky130_fd_sc_hd__a21oi_1
XFILLER_29_3 VGND VGND VPWR VPWR sky130_fd_sc_hd__fill_2
X_1302_ clkload9/A _1446_/D _0625_/B VGND VGND VPWR VPWR _1302_/Q sky130_fd_sc_hd__edfxtp_1
X_1233_ _1469_/CLK _1441_/D _0613_/A VGND VGND VPWR VPWR _1233_/Q sky130_fd_sc_hd__edfxtp_1
XTAP_TAPCELL_ROW_0_92 VGND VPWR sky130_fd_sc_hd__tapvpwrvgnd_1
XTAP_TAPCELL_ROW_0_81 VGND VPWR sky130_fd_sc_hd__tapvpwrvgnd_1
XFILLER_37_345 VGND VGND VPWR VPWR sky130_fd_sc_hd__fill_1
X_1164_ _1191_/A _1414_/D VGND VGND VPWR VPWR _1164_/Y sky130_fd_sc_hd__nand2_1
X_1095_ _1095_/A _1095_/B VGND VGND VPWR VPWR _1111_/A sky130_fd_sc_hd__nor2_1
XFILLER_20_289 VGND VGND VPWR VPWR sky130_fd_sc_hd__fill_2
X_0948_ _1120_/X _1317_/Q _1106_/A _1327_/Q VGND VGND VPWR VPWR _0949_/C sky130_fd_sc_hd__a22o_1
XTAP_TAPCELL_ROW_22_229 VGND VPWR sky130_fd_sc_hd__tapvpwrvgnd_1
X_0879_ _1089_/A _1213_/Q VGND VGND VPWR VPWR _0881_/A sky130_fd_sc_hd__nand2_1
XTAP_TAPCELL_ROW_30_284 VGND VPWR sky130_fd_sc_hd__tapvpwrvgnd_1
XFILLER_11_223 VGND VGND VPWR VPWR sky130_fd_sc_hd__fill_1
XFILLER_34_11 VGND VGND VPWR VPWR sky130_fd_sc_hd__fill_2
XFILLER_11_289 VGND VGND VPWR VPWR sky130_fd_sc_hd__decap_3
XFILLER_34_348 VGND VGND VPWR VPWR sky130_fd_sc_hd__decap_8
XFILLER_34_359 VGND VGND VPWR VPWR sky130_fd_sc_hd__fill_1
X_0802_ _1109_/A _1348_/Q VGND VGND VPWR VPWR _0803_/C sky130_fd_sc_hd__nand2_1
X_0733_ _0733_/A _0733_/B _0733_/C _1459_/Q VGND VGND VPWR VPWR _0734_/B sky130_fd_sc_hd__nand4_1
X_0664_ _0902_/A _1434_/Q VGND VGND VPWR VPWR _0666_/B sky130_fd_sc_hd__nand2_1
X_1216_ clkload1/A _1408_/D _1231_/DE VGND VGND VPWR VPWR _1216_/Q sky130_fd_sc_hd__edfxtp_1
XFILLER_25_337 VGND VGND VPWR VPWR sky130_fd_sc_hd__fill_2
X_1147_ _1128_/A _1122_/Y _1039_/A VGND VGND VPWR VPWR _1148_/B sky130_fd_sc_hd__a21oi_1
X_1078_ _1078_/A _1078_/B VGND VGND VPWR VPWR _1114_/A sky130_fd_sc_hd__nand2_1
XFILLER_29_44 VGND VGND VPWR VPWR sky130_fd_sc_hd__fill_1
XFILLER_16_315 VGND VGND VPWR VPWR sky130_fd_sc_hd__fill_1
XFILLER_31_329 VGND VGND VPWR VPWR sky130_fd_sc_hd__decap_6
XFILLER_19_164 VGND VGND VPWR VPWR sky130_fd_sc_hd__fill_1
XFILLER_34_178 VGND VGND VPWR VPWR sky130_fd_sc_hd__fill_2
X_1001_ _1076_/X _1287_/Q VGND VGND VPWR VPWR _1005_/A sky130_fd_sc_hd__nand2_1
X_0716_ _1145_/A _0716_/B VGND VGND VPWR VPWR _0858_/B sky130_fd_sc_hd__nor2_2
X_0647_ _0754_/A _0765_/B VGND VGND VPWR VPWR _0647_/Y sky130_fd_sc_hd__nor2_1
XFILLER_15_57 VGND VGND VPWR VPWR sky130_fd_sc_hd__decap_12
XFILLER_31_45 VGND VGND VPWR VPWR sky130_fd_sc_hd__fill_1
XFILLER_0_222 VGND VGND VPWR VPWR sky130_fd_sc_hd__fill_2
XFILLER_12_373 VGND VGND VPWR VPWR sky130_fd_sc_hd__decap_4
X_1481_ _1494_/CLK _1481_/D VGND VGND VPWR VPWR _1481_/Q sky130_fd_sc_hd__dfxtp_1
XFILLER_11_3 VGND VGND VPWR VPWR sky130_fd_sc_hd__fill_2
XFILLER_22_115 VGND VGND VPWR VPWR sky130_fd_sc_hd__fill_1
XFILLER_30_192 VGND VGND VPWR VPWR sky130_fd_sc_hd__fill_1
XFILLER_26_45 VGND VGND VPWR VPWR sky130_fd_sc_hd__decap_4
XFILLER_13_148 VGND VGND VPWR VPWR sky130_fd_sc_hd__decap_12
XFILLER_9_108 VGND VGND VPWR VPWR sky130_fd_sc_hd__decap_4
XTAP_TAPCELL_ROW_8_141 VGND VPWR sky130_fd_sc_hd__tapvpwrvgnd_1
X_0981_ _1100_/A _1274_/Q _1080_/A _1264_/Q _0980_/Y VGND VGND VPWR VPWR _0993_/B
+ sky130_fd_sc_hd__a221oi_2
XFILLER_12_192 VGND VGND VPWR VPWR sky130_fd_sc_hd__fill_1
XFILLER_8_141 VGND VGND VPWR VPWR sky130_fd_sc_hd__decap_12
XFILLER_8_130 VGND VGND VPWR VPWR sky130_fd_sc_hd__fill_1
X_1395_ clkload2/A _1411_/D _0650_/B VGND VGND VPWR VPWR _1395_/Q sky130_fd_sc_hd__edfxtp_1
X_1464_ clkload9/A _1464_/D VGND VGND VPWR VPWR _1464_/Q sky130_fd_sc_hd__dfxtp_1
Xfanout109 input13/X VGND VGND VPWR VPWR _0651_/A sky130_fd_sc_hd__clkdlybuf4s50_1
XFILLER_10_118 VGND VGND VPWR VPWR sky130_fd_sc_hd__fill_2
XFILLER_18_218 VGND VGND VPWR VPWR sky130_fd_sc_hd__fill_1
XTAP_TAPCELL_ROW_5_122 VGND VPWR sky130_fd_sc_hd__tapvpwrvgnd_1
XTAP_TAPCELL_ROW_28_268 VGND VPWR sky130_fd_sc_hd__tapvpwrvgnd_1
XFILLER_5_166 VGND VGND VPWR VPWR sky130_fd_sc_hd__fill_2
X_1180_ _1177_/Y _1179_/Y _0642_/A VGND VGND VPWR VPWR _1480_/D sky130_fd_sc_hd__a21oi_1
XTAP_TAPCELL_ROW_19_213 VGND VPWR sky130_fd_sc_hd__tapvpwrvgnd_1
Xclkbuf_leaf_12_clk clkbuf_leaf_4_clk/A VGND VGND VPWR VPWR clkload5/A sky130_fd_sc_hd__clkbuf_16
X_0964_ _1138_/B _1139_/B VGND VGND VPWR VPWR _1149_/A sky130_fd_sc_hd__nand2_2
X_0895_ _1206_/Q _0908_/A VGND VGND VPWR VPWR _0896_/B sky130_fd_sc_hd__nand2_1
X_1378_ clkload1/A _1410_/D _1391_/DE VGND VGND VPWR VPWR _1378_/Q sky130_fd_sc_hd__edfxtp_1
X_1447_ _1456_/CLK _1447_/D _1453_/DE VGND VGND VPWR VPWR _1447_/Q sky130_fd_sc_hd__edfxtp_1
XTAP_TAPCELL_ROW_2_103 VGND VPWR sky130_fd_sc_hd__tapvpwrvgnd_1
XFILLER_23_221 VGND VGND VPWR VPWR sky130_fd_sc_hd__decap_3
XTAP_TAPCELL_ROW_25_249 VGND VPWR sky130_fd_sc_hd__tapvpwrvgnd_1
XFILLER_14_298 VGND VGND VPWR VPWR sky130_fd_sc_hd__fill_2
Xfanout91 _1478_/Q VGND VGND VPWR VPWR _1414_/D sky130_fd_sc_hd__clkdlybuf4s50_1
Xfanout80 _1484_/Q VGND VGND VPWR VPWR _1452_/D sky130_fd_sc_hd__clkdlybuf4s50_1
XFILLER_9_37 VGND VGND VPWR VPWR sky130_fd_sc_hd__fill_1
X_0680_ _0680_/A VGND VGND VPWR VPWR _0680_/Y sky130_fd_sc_hd__inv_2
X_1301_ _1466_/CLK _1445_/D _1311_/DE VGND VGND VPWR VPWR _1301_/Q sky130_fd_sc_hd__edfxtp_1
Xclkbuf_leaf_1_clk clkbuf_leaf_4_clk/A VGND VGND VPWR VPWR clkload2/A sky130_fd_sc_hd__clkbuf_16
X_1232_ _1469_/CLK _1408_/D _0613_/A VGND VGND VPWR VPWR _1232_/Q sky130_fd_sc_hd__edfxtp_1
XTAP_TAPCELL_ROW_0_82 VGND VPWR sky130_fd_sc_hd__tapvpwrvgnd_1
X_1163_ _1160_/Y _1162_/Y _0642_/A VGND VGND VPWR VPWR _1485_/D sky130_fd_sc_hd__a21oi_1
X_1094_ _1094_/A _1094_/B VGND VGND VPWR VPWR _1095_/B sky130_fd_sc_hd__nand2_1
XFILLER_20_235 VGND VGND VPWR VPWR sky130_fd_sc_hd__fill_1
X_0947_ _1080_/A _1312_/Q _1076_/X _1319_/Q VGND VGND VPWR VPWR _0949_/B sky130_fd_sc_hd__a22o_1
XTAP_TAPCELL_ROW_30_285 VGND VPWR sky130_fd_sc_hd__tapvpwrvgnd_1
X_0878_ _0878_/A _1471_/Q VGND VGND VPWR VPWR _0882_/A sky130_fd_sc_hd__nand2_1
XFILLER_28_368 VGND VGND VPWR VPWR sky130_fd_sc_hd__decap_8
XFILLER_11_257 VGND VGND VPWR VPWR sky130_fd_sc_hd__fill_2
Xclkload0 clkload0/A VGND VGND VPWR VPWR clkload0/X sky130_fd_sc_hd__clkbuf_16
XFILLER_19_313 VGND VGND VPWR VPWR sky130_fd_sc_hd__fill_1
X_0801_ _0923_/A _1358_/Q VGND VGND VPWR VPWR _0803_/B sky130_fd_sc_hd__nand2_1
X_0732_ input3/X input4/X VGND VGND VPWR VPWR _0743_/A sky130_fd_sc_hd__nor2_1
X_0663_ _1099_/A _1427_/Q VGND VGND VPWR VPWR _0666_/A sky130_fd_sc_hd__nand2_1
XFILLER_6_283 VGND VGND VPWR VPWR sky130_fd_sc_hd__fill_1
XFILLER_37_132 VGND VGND VPWR VPWR sky130_fd_sc_hd__decap_3
X_1215_ _1456_/CLK _1423_/D _0619_/B VGND VGND VPWR VPWR _1215_/Q sky130_fd_sc_hd__edfxtp_1
X_1146_ _1144_/Y _1145_/Y _0716_/B VGND VGND VPWR VPWR _1146_/Y sky130_fd_sc_hd__a21oi_4
X_1077_ _1129_/B _1157_/B _1127_/B VGND VGND VPWR VPWR _1078_/B sky130_fd_sc_hd__o21ai_1
XFILLER_20_47 VGND VGND VPWR VPWR sky130_fd_sc_hd__fill_2
XFILLER_28_121 VGND VGND VPWR VPWR sky130_fd_sc_hd__decap_8
X_1000_ _1000_/A _1466_/Q VGND VGND VPWR VPWR _1006_/A sky130_fd_sc_hd__nand2_1
XFILLER_15_371 VGND VGND VPWR VPWR sky130_fd_sc_hd__decap_3
XFILLER_34_124 VGND VGND VPWR VPWR sky130_fd_sc_hd__decap_12
X_0715_ _0715_/A _0715_/B _0715_/C _0715_/D VGND VGND VPWR VPWR _0716_/B sky130_fd_sc_hd__nor4_4
X_0646_ _0646_/A VGND VGND VPWR VPWR _1457_/D sky130_fd_sc_hd__buf_2
XFILLER_25_113 VGND VGND VPWR VPWR sky130_fd_sc_hd__fill_1
X_1129_ _1155_/B _1129_/B VGND VGND VPWR VPWR _1157_/A sky130_fd_sc_hd__nor2_1
XFILLER_15_47 VGND VGND VPWR VPWR sky130_fd_sc_hd__decap_8
XFILLER_15_69 VGND VGND VPWR VPWR sky130_fd_sc_hd__decap_3
XFILLER_21_341 VGND VGND VPWR VPWR sky130_fd_sc_hd__fill_1
XFILLER_31_13 VGND VGND VPWR VPWR sky130_fd_sc_hd__fill_1
XFILLER_31_57 VGND VGND VPWR VPWR sky130_fd_sc_hd__fill_2
XFILLER_0_245 VGND VGND VPWR VPWR sky130_fd_sc_hd__fill_2
XPHY_EDGE_ROW_19_Right_19 VGND VGND VPWR VPWR sky130_fd_sc_hd__decap_3
XFILLER_8_334 VGND VGND VPWR VPWR sky130_fd_sc_hd__decap_6
X_1480_ clkload3/A _1480_/D VGND VGND VPWR VPWR _1480_/Q sky130_fd_sc_hd__dfxtp_1
XPHY_EDGE_ROW_28_Right_28 VGND VGND VPWR VPWR sky130_fd_sc_hd__decap_3
XPHY_EDGE_ROW_37_Right_37 VGND VGND VPWR VPWR sky130_fd_sc_hd__decap_3
X_0629_ _0629_/A _0629_/B VGND VGND VPWR VPWR _0630_/B sky130_fd_sc_hd__nor2_1
XFILLER_5_337 VGND VGND VPWR VPWR sky130_fd_sc_hd__decap_12
XTAP_TAPCELL_ROW_8_142 VGND VPWR sky130_fd_sc_hd__tapvpwrvgnd_1
X_0980_ _0980_/A _0980_/B VGND VGND VPWR VPWR _0980_/Y sky130_fd_sc_hd__nand2_1
XTAP_TAPCELL_ROW_14_177 VGND VPWR sky130_fd_sc_hd__tapvpwrvgnd_1
XFILLER_8_197 VGND VGND VPWR VPWR sky130_fd_sc_hd__decap_4
XFILLER_8_153 VGND VGND VPWR VPWR sky130_fd_sc_hd__decap_6
X_1394_ clkload2/A _1410_/D _0650_/B VGND VGND VPWR VPWR _1394_/Q sky130_fd_sc_hd__edfxtp_1
X_1463_ clkload4/A _1463_/D VGND VGND VPWR VPWR _1463_/Q sky130_fd_sc_hd__dfxtp_1
XFILLER_12_59 VGND VGND VPWR VPWR sky130_fd_sc_hd__fill_1
Xhold120 _1470_/Q VGND VGND VPWR VPWR hold120/X sky130_fd_sc_hd__dlygate4sd3_1
XTAP_TAPCELL_ROW_5_123 VGND VPWR sky130_fd_sc_hd__tapvpwrvgnd_1
XTAP_TAPCELL_ROW_28_269 VGND VPWR sky130_fd_sc_hd__tapvpwrvgnd_1
XTAP_TAPCELL_ROW_11_158 VGND VPWR sky130_fd_sc_hd__tapvpwrvgnd_1
XFILLER_5_189 VGND VGND VPWR VPWR sky130_fd_sc_hd__decap_6
XTAP_TAPCELL_ROW_19_214 VGND VPWR sky130_fd_sc_hd__tapvpwrvgnd_1
X_0963_ _0963_/A _0963_/B _0963_/C _0963_/D VGND VGND VPWR VPWR _1137_/B sky130_fd_sc_hd__nand4_2
X_0894_ _1215_/Q _0894_/B VGND VGND VPWR VPWR _0899_/A sky130_fd_sc_hd__nor2_1
X_1377_ clkload1/A _1409_/D _1391_/DE VGND VGND VPWR VPWR _1377_/Q sky130_fd_sc_hd__edfxtp_1
X_1446_ _1456_/CLK _1446_/D _1453_/DE VGND VGND VPWR VPWR _1446_/Q sky130_fd_sc_hd__edfxtp_1
XTAP_TAPCELL_ROW_2_104 VGND VPWR sky130_fd_sc_hd__tapvpwrvgnd_1
XFILLER_0_29 VGND VGND VPWR VPWR sky130_fd_sc_hd__decap_4
XFILLER_14_200 VGND VGND VPWR VPWR sky130_fd_sc_hd__decap_6
Xfanout92 _1478_/Q VGND VGND VPWR VPWR _1446_/D sky130_fd_sc_hd__clkdlybuf4s50_1
Xfanout81 _1483_/Q VGND VGND VPWR VPWR _1419_/D sky130_fd_sc_hd__clkdlybuf4s50_1
Xfanout70 _1489_/Q VGND VGND VPWR VPWR _1104_/A sky130_fd_sc_hd__clkdlybuf4s50_1
X_1300_ _1466_/CLK _1444_/D _1311_/DE VGND VGND VPWR VPWR _1300_/Q sky130_fd_sc_hd__edfxtp_1
X_1231_ clkload6/A _1423_/D _1231_/DE VGND VGND VPWR VPWR _1231_/Q sky130_fd_sc_hd__edfxtp_1
X_1162_ _1192_/A _1421_/D VGND VGND VPWR VPWR _1162_/Y sky130_fd_sc_hd__nand2_1
XTAP_TAPCELL_ROW_0_83 VGND VPWR sky130_fd_sc_hd__tapvpwrvgnd_1
X_1093_ _1093_/A _1240_/Q VGND VGND VPWR VPWR _1094_/B sky130_fd_sc_hd__nand2_1
X_0946_ _0946_/A _1464_/Q VGND VGND VPWR VPWR _0949_/A sky130_fd_sc_hd__nand2_1
X_0877_ _1079_/A _1207_/Q VGND VGND VPWR VPWR _0878_/A sky130_fd_sc_hd__nand2_1
XTAP_TAPCELL_ROW_30_286 VGND VPWR sky130_fd_sc_hd__tapvpwrvgnd_1
XFILLER_9_281 VGND VGND VPWR VPWR sky130_fd_sc_hd__decap_6
X_1429_ _1456_/CLK _1445_/D _1439_/DE VGND VGND VPWR VPWR _1429_/Q sky130_fd_sc_hd__edfxtp_1
XFILLER_18_47 VGND VGND VPWR VPWR sky130_fd_sc_hd__decap_8
XFILLER_11_225 VGND VGND VPWR VPWR sky130_fd_sc_hd__decap_8
XFILLER_11_269 VGND VGND VPWR VPWR sky130_fd_sc_hd__decap_8
Xclkload1 clkload1/A VGND VGND VPWR VPWR clkload1/X sky130_fd_sc_hd__clkbuf_8
XFILLER_1_3 VGND VGND VPWR VPWR sky130_fd_sc_hd__decap_8
XFILLER_19_325 VGND VGND VPWR VPWR sky130_fd_sc_hd__fill_1
Xload_slew57 _1026_/A VGND VGND VPWR VPWR _1107_/B sky130_fd_sc_hd__buf_4
XPHY_EDGE_ROW_28_Left_68 VGND VGND VPWR VPWR sky130_fd_sc_hd__decap_3
X_0800_ _1106_/A _1359_/Q VGND VGND VPWR VPWR _0803_/A sky130_fd_sc_hd__nand2_1
X_0731_ _1080_/A _1392_/Q VGND VGND VPWR VPWR _0733_/C sky130_fd_sc_hd__nand2_1
XFILLER_6_251 VGND VGND VPWR VPWR sky130_fd_sc_hd__fill_1
X_0662_ _0662_/A _0662_/B _0662_/C _0662_/D VGND VGND VPWR VPWR _0685_/B sky130_fd_sc_hd__nand4_1
XFILLER_37_199 VGND VGND VPWR VPWR sky130_fd_sc_hd__fill_1
X_1214_ clkload6/A _1422_/D _0619_/B VGND VGND VPWR VPWR _1214_/Q sky130_fd_sc_hd__edfxtp_1
X_1145_ _1145_/A VGND VGND VPWR VPWR _1145_/Y sky130_fd_sc_hd__inv_1
X_1076_ _1079_/A VGND VGND VPWR VPWR _1076_/X sky130_fd_sc_hd__buf_6
XFILLER_20_15 VGND VGND VPWR VPWR sky130_fd_sc_hd__decap_4
X_0929_ _1093_/A _1224_/Q VGND VGND VPWR VPWR _0933_/A sky130_fd_sc_hd__nand2_1
XFILLER_29_57 VGND VGND VPWR VPWR sky130_fd_sc_hd__fill_1
XFILLER_3_265 VGND VGND VPWR VPWR sky130_fd_sc_hd__decap_6
XFILLER_19_111 VGND VGND VPWR VPWR sky130_fd_sc_hd__fill_1
XFILLER_34_136 VGND VGND VPWR VPWR sky130_fd_sc_hd__decap_4
X_0714_ _0714_/A _0714_/B _0714_/C _0714_/D VGND VGND VPWR VPWR _0715_/D sky130_fd_sc_hd__nand4_1
X_0645_ hold125/X _1437_/DE _0651_/A VGND VGND VPWR VPWR _0646_/A sky130_fd_sc_hd__o21ba_2
XFILLER_15_15 VGND VGND VPWR VPWR sky130_fd_sc_hd__fill_1
XFILLER_25_169 VGND VGND VPWR VPWR sky130_fd_sc_hd__fill_1
X_1128_ _1128_/A _1128_/B _1128_/C VGND VGND VPWR VPWR _1155_/B sky130_fd_sc_hd__nand3_1
X_1059_ _1263_/Q VGND VGND VPWR VPWR _1060_/A sky130_fd_sc_hd__inv_1
XFILLER_21_375 VGND VGND VPWR VPWR sky130_fd_sc_hd__decap_3
XFILLER_31_69 VGND VGND VPWR VPWR sky130_fd_sc_hd__fill_1
Xoutput14 _1146_/Y VGND VGND VPWR VPWR match_addr[0] sky130_fd_sc_hd__buf_2
XFILLER_0_279 VGND VGND VPWR VPWR sky130_fd_sc_hd__fill_1
XFILLER_30_172 VGND VGND VPWR VPWR sky130_fd_sc_hd__decap_12
XTAP_TAPCELL_ROW_17_197 VGND VPWR sky130_fd_sc_hd__tapvpwrvgnd_1
X_0628_ _0628_/A VGND VGND VPWR VPWR _1464_/D sky130_fd_sc_hd__buf_2
XPHY_EDGE_ROW_15_Left_55 VGND VGND VPWR VPWR sky130_fd_sc_hd__decap_3
XFILLER_5_349 VGND VGND VPWR VPWR sky130_fd_sc_hd__fill_2
XTAP_TAPCELL_ROW_8_143 VGND VPWR sky130_fd_sc_hd__tapvpwrvgnd_1
XFILLER_16_91 VGND VGND VPWR VPWR sky130_fd_sc_hd__fill_1
XTAP_TAPCELL_ROW_14_178 VGND VPWR sky130_fd_sc_hd__tapvpwrvgnd_1
X_1462_ clkload3/A _1462_/D VGND VGND VPWR VPWR _1462_/Q sky130_fd_sc_hd__dfxtp_1
X_1393_ clkload5/A _1441_/D _1407_/DE VGND VGND VPWR VPWR _1393_/Q sky130_fd_sc_hd__edfxtp_1
Xhold110 _1471_/Q VGND VGND VPWR VPWR _0619_/A sky130_fd_sc_hd__dlygate4sd3_1
Xhold121 _1456_/Q VGND VGND VPWR VPWR hold121/X sky130_fd_sc_hd__dlygate4sd3_1
XTAP_TAPCELL_ROW_5_124 VGND VPWR sky130_fd_sc_hd__tapvpwrvgnd_1
XFILLER_26_253 VGND VGND VPWR VPWR sky130_fd_sc_hd__decap_12
XTAP_TAPCELL_ROW_11_159 VGND VPWR sky130_fd_sc_hd__tapvpwrvgnd_1
XFILLER_5_113 VGND VGND VPWR VPWR sky130_fd_sc_hd__decap_4
XFILLER_5_102 VGND VGND VPWR VPWR sky130_fd_sc_hd__decap_8
XFILLER_1_330 VGND VGND VPWR VPWR sky130_fd_sc_hd__decap_6
XFILLER_1_363 VGND VGND VPWR VPWR sky130_fd_sc_hd__decap_12
XTAP_TAPCELL_ROW_19_215 VGND VPWR sky130_fd_sc_hd__tapvpwrvgnd_1
X_0962_ _1063_/A _1323_/Q _0958_/Y _0961_/Y VGND VGND VPWR VPWR _0963_/D sky130_fd_sc_hd__a211oi_1
X_0893_ _0923_/A _1214_/Q VGND VGND VPWR VPWR _0894_/B sky130_fd_sc_hd__nand2_1
X_1445_ _1456_/CLK _1445_/D _1455_/DE VGND VGND VPWR VPWR _1445_/Q sky130_fd_sc_hd__edfxtp_1
X_1376_ clkload1/A _1408_/D _1391_/DE VGND VGND VPWR VPWR _1376_/Q sky130_fd_sc_hd__edfxtp_1
XTAP_TAPCELL_ROW_2_105 VGND VPWR sky130_fd_sc_hd__tapvpwrvgnd_1
XFILLER_23_15 VGND VGND VPWR VPWR sky130_fd_sc_hd__fill_1
XFILLER_14_267 VGND VGND VPWR VPWR sky130_fd_sc_hd__decap_6
Xfanout93 _1477_/Q VGND VGND VPWR VPWR _1413_/D sky130_fd_sc_hd__clkdlybuf4s50_1
Xfanout82 _1483_/Q VGND VGND VPWR VPWR _1451_/D sky130_fd_sc_hd__clkdlybuf4s50_1
Xfanout71 _1049_/A VGND VGND VPWR VPWR _1080_/A sky130_fd_sc_hd__clkdlybuf4s50_1
Xfanout60 _1494_/Q VGND VGND VPWR VPWR _1090_/B sky130_fd_sc_hd__clkdlybuf4s50_1
X_1230_ clkload7/A _1422_/D _1231_/DE VGND VGND VPWR VPWR _1230_/Q sky130_fd_sc_hd__edfxtp_1
X_1161_ _1198_/A VGND VGND VPWR VPWR _1192_/A sky130_fd_sc_hd__buf_1
X_1092_ _1092_/A _1241_/Q VGND VGND VPWR VPWR _1094_/A sky130_fd_sc_hd__nand2_1
XTAP_TAPCELL_ROW_0_84 VGND VPWR sky130_fd_sc_hd__tapvpwrvgnd_1
XFILLER_20_248 VGND VGND VPWR VPWR sky130_fd_sc_hd__decap_4
X_0945_ _1026_/A _1326_/Q VGND VGND VPWR VPWR _0946_/A sky130_fd_sc_hd__nand2_1
X_0876_ _0909_/B _1063_/A _1199_/B1 _0865_/Y VGND VGND VPWR VPWR _1493_/D sky130_fd_sc_hd__a211oi_2
XTAP_TAPCELL_ROW_30_287 VGND VPWR sky130_fd_sc_hd__tapvpwrvgnd_1
X_1428_ _1469_/CLK _1444_/D _1439_/DE VGND VGND VPWR VPWR _1428_/Q sky130_fd_sc_hd__edfxtp_1
XFILLER_18_37 VGND VGND VPWR VPWR sky130_fd_sc_hd__decap_4
X_1359_ clkload3/A _1423_/D _0641_/B VGND VGND VPWR VPWR _1359_/Q sky130_fd_sc_hd__edfxtp_1
Xclkload2 clkload2/A VGND VGND VPWR VPWR clkload2/X sky130_fd_sc_hd__clkbuf_8
XPHY_EDGE_ROW_3_Left_43 VGND VGND VPWR VPWR sky130_fd_sc_hd__decap_3
X_0730_ _1026_/A _1406_/Q VGND VGND VPWR VPWR _0733_/B sky130_fd_sc_hd__nand2_1
X_0661_ _0908_/A _1430_/Q VGND VGND VPWR VPWR _0662_/D sky130_fd_sc_hd__nand2_1
XFILLER_27_3 VGND VGND VPWR VPWR sky130_fd_sc_hd__decap_4
X_1213_ clkload6/A _1421_/D _0619_/B VGND VGND VPWR VPWR _1213_/Q sky130_fd_sc_hd__edfxtp_1
X_1144_ _1144_/A _1144_/B VGND VGND VPWR VPWR _1144_/Y sky130_fd_sc_hd__nand2_2
X_1075_ _1133_/B VGND VGND VPWR VPWR _1127_/B sky130_fd_sc_hd__inv_1
XFILLER_20_27 VGND VGND VPWR VPWR sky130_fd_sc_hd__fill_1
X_0928_ _0928_/A _0928_/B VGND VGND VPWR VPWR _0938_/B sky130_fd_sc_hd__nor2_1
X_0859_ _1141_/B _1140_/B VGND VGND VPWR VPWR _1150_/A sky130_fd_sc_hd__nand2_2
XFILLER_6_29 VGND VGND VPWR VPWR sky130_fd_sc_hd__fill_2
XFILLER_3_222 VGND VGND VPWR VPWR sky130_fd_sc_hd__fill_2
XFILLER_13_9 VGND VGND VPWR VPWR sky130_fd_sc_hd__fill_1
XFILLER_30_365 VGND VGND VPWR VPWR sky130_fd_sc_hd__decap_12
X_0713_ _1104_/A _1442_/Q VGND VGND VPWR VPWR _0714_/D sky130_fd_sc_hd__nand2_1
X_0644_ _0754_/A _0776_/B VGND VGND VPWR VPWR _0644_/Y sky130_fd_sc_hd__nor2_1
XFILLER_25_137 VGND VGND VPWR VPWR sky130_fd_sc_hd__fill_2
X_1127_ _1127_/A _1127_/B VGND VGND VPWR VPWR _1128_/A sky130_fd_sc_hd__nor2_1
X_1058_ _1120_/X _1253_/Q VGND VGND VPWR VPWR _1058_/Y sky130_fd_sc_hd__nand2_1
XFILLER_31_37 VGND VGND VPWR VPWR sky130_fd_sc_hd__decap_8
XFILLER_0_225 VGND VGND VPWR VPWR sky130_fd_sc_hd__decap_12
Xoutput15 _1152_/X VGND VGND VPWR VPWR match_addr[1] sky130_fd_sc_hd__buf_2
XPHY_EDGE_ROW_1_Right_1 VGND VGND VPWR VPWR sky130_fd_sc_hd__decap_3
XFILLER_12_321 VGND VGND VPWR VPWR sky130_fd_sc_hd__fill_1
XFILLER_21_81 VGND VGND VPWR VPWR sky130_fd_sc_hd__decap_6
XFILLER_39_207 VGND VGND VPWR VPWR sky130_fd_sc_hd__fill_1
XFILLER_30_184 VGND VGND VPWR VPWR sky130_fd_sc_hd__decap_8
XTAP_TAPCELL_ROW_17_198 VGND VPWR sky130_fd_sc_hd__tapvpwrvgnd_1
X_0627_ hold123/X _1326_/DE _0651_/A VGND VGND VPWR VPWR _0628_/A sky130_fd_sc_hd__o21ba_2
XFILLER_5_328 VGND VGND VPWR VPWR sky130_fd_sc_hd__decap_8
XTAP_TAPCELL_ROW_8_144 VGND VPWR sky130_fd_sc_hd__tapvpwrvgnd_1
XPHY_EDGE_ROW_32_Left_72 VGND VGND VPWR VPWR sky130_fd_sc_hd__decap_3
XTAP_TAPCELL_ROW_14_179 VGND VPWR sky130_fd_sc_hd__tapvpwrvgnd_1
XFILLER_8_100 VGND VGND VPWR VPWR sky130_fd_sc_hd__fill_1
XFILLER_4_372 VGND VGND VPWR VPWR sky130_fd_sc_hd__decap_6
X_1392_ _1459_/CLK _1440_/D _1407_/DE VGND VGND VPWR VPWR _1392_/Q sky130_fd_sc_hd__edfxtp_1
X_1461_ clkload4/A _1461_/D VGND VGND VPWR VPWR _1461_/Q sky130_fd_sc_hd__dfxtp_1
Xhold122 _1468_/Q VGND VGND VPWR VPWR hold122/X sky130_fd_sc_hd__dlygate4sd3_1
Xhold111 _1462_/Q VGND VGND VPWR VPWR _0641_/A sky130_fd_sc_hd__dlygate4sd3_1
XFILLER_26_221 VGND VGND VPWR VPWR sky130_fd_sc_hd__decap_6
XFILLER_26_265 VGND VGND VPWR VPWR sky130_fd_sc_hd__decap_12
XFILLER_37_47 VGND VGND VPWR VPWR sky130_fd_sc_hd__fill_1
XFILLER_5_169 VGND VGND VPWR VPWR sky130_fd_sc_hd__fill_2
XFILLER_1_375 VGND VGND VPWR VPWR sky130_fd_sc_hd__decap_3
X_0961_ _0961_/A _0961_/B VGND VGND VPWR VPWR _0961_/Y sky130_fd_sc_hd__nand2_1
X_0892_ _0892_/A _0892_/B VGND VGND VPWR VPWR _0900_/A sky130_fd_sc_hd__nor2_1
X_1375_ clkload4/A _1423_/D _1375_/DE VGND VGND VPWR VPWR _1375_/Q sky130_fd_sc_hd__edfxtp_1
X_1444_ _1469_/CLK _1444_/D _1455_/DE VGND VGND VPWR VPWR _1444_/Q sky130_fd_sc_hd__edfxtp_1
Xclkbuf_leaf_4_clk clkbuf_leaf_4_clk/A VGND VGND VPWR VPWR clkload4/A sky130_fd_sc_hd__clkbuf_16
XFILLER_23_235 VGND VGND VPWR VPWR sky130_fd_sc_hd__fill_2
XFILLER_23_279 VGND VGND VPWR VPWR sky130_fd_sc_hd__fill_1
Xfanout94 _1477_/Q VGND VGND VPWR VPWR _1445_/D sky130_fd_sc_hd__clkdlybuf4s50_1
Xfanout83 _1482_/Q VGND VGND VPWR VPWR _1418_/D sky130_fd_sc_hd__clkdlybuf4s50_1
Xfanout72 _1488_/Q VGND VGND VPWR VPWR _1049_/A sky130_fd_sc_hd__clkdlybuf4s50_1
Xfanout61 _1493_/Q VGND VGND VPWR VPWR _0902_/A sky130_fd_sc_hd__clkdlybuf4s50_1
Xfanout50 _0624_/Y VGND VGND VPWR VPWR _1311_/DE sky130_fd_sc_hd__clkdlybuf4s50_1
XTAP_TAPCELL_ROW_0_85 VGND VPWR sky130_fd_sc_hd__tapvpwrvgnd_1
X_1160_ _1191_/A _1415_/D VGND VGND VPWR VPWR _1160_/Y sky130_fd_sc_hd__nand2_1
X_1091_ _1091_/A _1091_/B VGND VGND VPWR VPWR _1095_/A sky130_fd_sc_hd__nand2_1
X_0944_ _0944_/A _0944_/B _0944_/C VGND VGND VPWR VPWR _0972_/A sky130_fd_sc_hd__nand3_1
X_0875_ _0875_/A _0875_/B VGND VGND VPWR VPWR _0892_/A sky130_fd_sc_hd__nand2_1
X_1358_ clkload3/A _1422_/D _0641_/B VGND VGND VPWR VPWR _1358_/Q sky130_fd_sc_hd__edfxtp_1
X_1427_ clkload5/A _1443_/D _1434_/DE VGND VGND VPWR VPWR _1427_/Q sky130_fd_sc_hd__edfxtp_1
X_1289_ clkload8/A _1449_/D _1295_/DE VGND VGND VPWR VPWR _1289_/Q sky130_fd_sc_hd__edfxtp_1
XTAP_TAPCELL_ROW_38_333 VGND VPWR sky130_fd_sc_hd__tapvpwrvgnd_1
Xclkload3 clkload3/A VGND VGND VPWR VPWR clkload3/X sky130_fd_sc_hd__clkbuf_2
XFILLER_19_305 VGND VGND VPWR VPWR sky130_fd_sc_hd__decap_8
XFILLER_27_371 VGND VGND VPWR VPWR sky130_fd_sc_hd__decap_6
X_0660_ _1424_/Q _1080_/A VGND VGND VPWR VPWR _0662_/C sky130_fd_sc_hd__nand2_1
X_1212_ clkload5/A _1420_/D _1212_/DE VGND VGND VPWR VPWR _1212_/Q sky130_fd_sc_hd__edfxtp_1
X_1143_ _1143_/A _1143_/B VGND VGND VPWR VPWR _1144_/A sky130_fd_sc_hd__nand2_1
X_1074_ _1074_/A _1074_/B VGND VGND VPWR VPWR _1133_/B sky130_fd_sc_hd__nand2_1
XTAP_TAPCELL_ROW_35_314 VGND VPWR sky130_fd_sc_hd__tapvpwrvgnd_1
X_0927_ _0927_/A _0927_/B VGND VGND VPWR VPWR _0928_/B sky130_fd_sc_hd__nand2_1
X_0858_ _0858_/A _0858_/B VGND VGND VPWR VPWR _0967_/A sky130_fd_sc_hd__nand2_2
X_0789_ _0932_/A _1346_/Q VGND VGND VPWR VPWR _0789_/Y sky130_fd_sc_hd__nand2_1
XFILLER_28_168 VGND VGND VPWR VPWR sky130_fd_sc_hd__decap_4
XFILLER_29_48 VGND VGND VPWR VPWR sky130_fd_sc_hd__decap_8
XFILLER_19_113 VGND VGND VPWR VPWR sky130_fd_sc_hd__decap_6
XFILLER_15_341 VGND VGND VPWR VPWR sky130_fd_sc_hd__fill_1
XFILLER_15_363 VGND VGND VPWR VPWR sky130_fd_sc_hd__decap_8
XFILLER_30_377 VGND VGND VPWR VPWR sky130_fd_sc_hd__fill_1
X_0712_ _1103_/A _1444_/Q VGND VGND VPWR VPWR _0714_/C sky130_fd_sc_hd__nand2_1
X_0643_ _1167_/B input3/X VGND VGND VPWR VPWR _0776_/A sky130_fd_sc_hd__nand2_1
X_1126_ _1126_/A _1126_/B VGND VGND VPWR VPWR _1126_/Y sky130_fd_sc_hd__nand2_4
XFILLER_21_311 VGND VGND VPWR VPWR sky130_fd_sc_hd__fill_1
X_1057_ _1103_/A _1252_/Q VGND VGND VPWR VPWR _1057_/Y sky130_fd_sc_hd__nand2_1
XFILLER_0_237 VGND VGND VPWR VPWR sky130_fd_sc_hd__decap_8
Xoutput16 _1156_/Y VGND VGND VPWR VPWR match_addr[2] sky130_fd_sc_hd__buf_2
XFILLER_12_377 VGND VGND VPWR VPWR sky130_fd_sc_hd__fill_1
Xclkbuf_0_clk clk VGND VGND VPWR VPWR clkbuf_0_clk/X sky130_fd_sc_hd__clkbuf_16
XTAP_TAPCELL_ROW_17_199 VGND VPWR sky130_fd_sc_hd__tapvpwrvgnd_1
X_0626_ _0651_/A _0626_/B VGND VGND VPWR VPWR _1465_/D sky130_fd_sc_hd__nor2_2
XPHY_EDGE_ROW_15_Right_15 VGND VGND VPWR VPWR sky130_fd_sc_hd__decap_3
X_1109_ _1109_/A VGND VGND VPWR VPWR _1120_/A sky130_fd_sc_hd__inv_12
XPHY_EDGE_ROW_24_Right_24 VGND VGND VPWR VPWR sky130_fd_sc_hd__decap_3
XFILLER_13_119 VGND VGND VPWR VPWR sky130_fd_sc_hd__fill_1
XPHY_EDGE_ROW_33_Right_33 VGND VGND VPWR VPWR sky130_fd_sc_hd__decap_3
XFILLER_8_189 VGND VGND VPWR VPWR sky130_fd_sc_hd__fill_2
X_1391_ clkload1/A _1423_/D _1391_/DE VGND VGND VPWR VPWR _1391_/Q sky130_fd_sc_hd__edfxtp_1
X_1460_ clkload1/A _1460_/D VGND VGND VPWR VPWR _1460_/Q sky130_fd_sc_hd__dfxtp_1
Xhold123 _1464_/Q VGND VGND VPWR VPWR hold123/X sky130_fd_sc_hd__dlygate4sd3_1
Xhold112 _1461_/Q VGND VGND VPWR VPWR _0634_/A sky130_fd_sc_hd__dlygate4sd3_1
X_0609_ _1197_/A input7/X VGND VGND VPWR VPWR _0609_/Y sky130_fd_sc_hd__nand2_1
XFILLER_26_277 VGND VGND VPWR VPWR sky130_fd_sc_hd__fill_2
XFILLER_32_269 VGND VGND VPWR VPWR sky130_fd_sc_hd__fill_1
X_0960_ _1046_/A _1320_/Q VGND VGND VPWR VPWR _0961_/B sky130_fd_sc_hd__nand2_1
X_0891_ _0891_/A _0891_/B VGND VGND VPWR VPWR _0892_/B sky130_fd_sc_hd__nand2_1
X_1374_ _1494_/CLK _1422_/D _1375_/DE VGND VGND VPWR VPWR _1374_/Q sky130_fd_sc_hd__edfxtp_1
X_1443_ _1459_/CLK _1443_/D _1453_/DE VGND VGND VPWR VPWR _1443_/Q sky130_fd_sc_hd__edfxtp_1
XFILLER_4_96 VGND VGND VPWR VPWR sky130_fd_sc_hd__fill_2
XFILLER_23_225 VGND VGND VPWR VPWR sky130_fd_sc_hd__decap_6
XFILLER_14_258 VGND VGND VPWR VPWR sky130_fd_sc_hd__fill_1
Xfanout73 _1487_/Q VGND VGND VPWR VPWR _1423_/D sky130_fd_sc_hd__clkdlybuf4s50_1
Xfanout62 _1493_/Q VGND VGND VPWR VPWR _1100_/A sky130_fd_sc_hd__clkdlybuf4s50_1
Xfanout51 _0621_/Y VGND VGND VPWR VPWR _1277_/DE sky130_fd_sc_hd__clkdlybuf4s50_1
Xfanout40 _0647_/Y VGND VGND VPWR VPWR _1455_/DE sky130_fd_sc_hd__clkdlybuf4s50_1
XTAP_TAPCELL_ROW_24_242 VGND VPWR sky130_fd_sc_hd__tapvpwrvgnd_1
Xfanout95 _1476_/Q VGND VGND VPWR VPWR _1412_/D sky130_fd_sc_hd__clkdlybuf4s50_1
Xfanout84 _1482_/Q VGND VGND VPWR VPWR _1450_/D sky130_fd_sc_hd__clkdlybuf4s50_1
XTAP_TAPCELL_ROW_0_86 VGND VPWR sky130_fd_sc_hd__tapvpwrvgnd_1
X_1090_ _1244_/Q _1090_/B VGND VGND VPWR VPWR _1091_/B sky130_fd_sc_hd__nand2_1
XFILLER_20_206 VGND VGND VPWR VPWR sky130_fd_sc_hd__decap_4
XFILLER_20_239 VGND VGND VPWR VPWR sky130_fd_sc_hd__decap_6
Xclkload10 _1466_/CLK VGND VGND VPWR VPWR clkload10/Y sky130_fd_sc_hd__bufinv_16
X_0943_ _1099_/A VGND VGND VPWR VPWR _0943_/X sky130_fd_sc_hd__buf_6
X_0874_ _0874_/A _0874_/B VGND VGND VPWR VPWR _0875_/B sky130_fd_sc_hd__nor2_1
XFILLER_9_262 VGND VGND VPWR VPWR sky130_fd_sc_hd__decap_12
XFILLER_28_306 VGND VGND VPWR VPWR sky130_fd_sc_hd__fill_2
X_1288_ clkload8/A _1448_/D _1295_/DE VGND VGND VPWR VPWR _1288_/Q sky130_fd_sc_hd__edfxtp_1
X_1357_ clkload2/A _1421_/D _1357_/DE VGND VGND VPWR VPWR _1357_/Q sky130_fd_sc_hd__edfxtp_1
X_1426_ _1469_/CLK _1442_/D _1439_/DE VGND VGND VPWR VPWR _1426_/Q sky130_fd_sc_hd__edfxtp_1
XTAP_TAPCELL_ROW_38_334 VGND VPWR sky130_fd_sc_hd__tapvpwrvgnd_1
Xclkload4 clkload4/A VGND VGND VPWR VPWR clkload4/Y sky130_fd_sc_hd__inv_1
XTAP_TAPCELL_ROW_21_223 VGND VPWR sky130_fd_sc_hd__tapvpwrvgnd_1
XFILLER_19_317 VGND VGND VPWR VPWR sky130_fd_sc_hd__decap_8
XFILLER_34_309 VGND VGND VPWR VPWR sky130_fd_sc_hd__decap_4
Xload_slew49 _1304_/DE VGND VGND VPWR VPWR _0625_/B sky130_fd_sc_hd__buf_4
XFILLER_24_93 VGND VGND VPWR VPWR sky130_fd_sc_hd__fill_1
X_1211_ clkload5/A _1419_/D _1212_/DE VGND VGND VPWR VPWR _1211_/Q sky130_fd_sc_hd__edfxtp_1
X_1142_ _1043_/B _1120_/X _1193_/B1 _1131_/Y VGND VGND VPWR VPWR _1490_/D sky130_fd_sc_hd__a211oi_2
XFILLER_33_364 VGND VGND VPWR VPWR sky130_fd_sc_hd__decap_12
X_1073_ _1073_/A _1073_/B _1073_/C VGND VGND VPWR VPWR _1074_/B sky130_fd_sc_hd__nor3_1
XTAP_TAPCELL_ROW_35_315 VGND VPWR sky130_fd_sc_hd__tapvpwrvgnd_1
X_0926_ _1223_/Q _1222_/Q VGND VGND VPWR VPWR _0927_/B sky130_fd_sc_hd__nand2_1
X_0857_ _0857_/A _0857_/B VGND VGND VPWR VPWR _0944_/A sky130_fd_sc_hd__nor2_1
X_1409_ clkload1/A _1409_/D _1423_/DE VGND VGND VPWR VPWR _1409_/Q sky130_fd_sc_hd__edfxtp_1
X_0788_ _1351_/Q VGND VGND VPWR VPWR _0788_/Y sky130_fd_sc_hd__inv_1
XFILLER_3_202 VGND VGND VPWR VPWR sky130_fd_sc_hd__decap_12
XFILLER_15_353 VGND VGND VPWR VPWR sky130_fd_sc_hd__fill_2
XFILLER_19_169 VGND VGND VPWR VPWR sky130_fd_sc_hd__fill_2
XFILLER_27_180 VGND VGND VPWR VPWR sky130_fd_sc_hd__decap_3
XFILLER_35_81 VGND VGND VPWR VPWR sky130_fd_sc_hd__fill_2
X_0711_ _1106_/A _1455_/Q _0708_/Y VGND VGND VPWR VPWR _0714_/B sky130_fd_sc_hd__a21oi_1
X_0642_ _0642_/A _0642_/B VGND VGND VPWR VPWR _1462_/D sky130_fd_sc_hd__nor2_1
XFILLER_25_117 VGND VGND VPWR VPWR sky130_fd_sc_hd__decap_12
X_1125_ _1125_/A VGND VGND VPWR VPWR _1126_/B sky130_fd_sc_hd__inv_2
X_1056_ _1083_/A _1254_/Q VGND VGND VPWR VPWR _1056_/Y sky130_fd_sc_hd__nand2_1
Xoutput17 _1157_/Y VGND VGND VPWR VPWR match_addr[3] sky130_fd_sc_hd__buf_2
X_0909_ input9/X _0909_/B VGND VGND VPWR VPWR _0909_/Y sky130_fd_sc_hd__nor2_1
XFILLER_24_183 VGND VGND VPWR VPWR sky130_fd_sc_hd__fill_2
X_0625_ _0625_/A _0625_/B VGND VGND VPWR VPWR _0626_/B sky130_fd_sc_hd__nor2_1
X_1108_ _1108_/A _1108_/B VGND VGND VPWR VPWR _1110_/B sky130_fd_sc_hd__nand2_1
X_1039_ _1039_/A _1148_/A VGND VGND VPWR VPWR _1155_/A sky130_fd_sc_hd__nor2_1
XFILLER_5_319 VGND VGND VPWR VPWR sky130_fd_sc_hd__decap_6
XFILLER_29_231 VGND VGND VPWR VPWR sky130_fd_sc_hd__fill_1
X_1390_ clkload1/A _1422_/D _1391_/DE VGND VGND VPWR VPWR _1390_/Q sky130_fd_sc_hd__edfxtp_1
XFILLER_35_223 VGND VGND VPWR VPWR sky130_fd_sc_hd__fill_1
XFILLER_35_267 VGND VGND VPWR VPWR sky130_fd_sc_hd__decap_12
XPHY_EDGE_ROW_19_Left_59 VGND VGND VPWR VPWR sky130_fd_sc_hd__decap_3
Xhold124 _1460_/Q VGND VGND VPWR VPWR hold124/X sky130_fd_sc_hd__dlygate4sd3_1
Xhold113 _1463_/Q VGND VGND VPWR VPWR _0638_/A sky130_fd_sc_hd__dlygate4sd3_1
X_0608_ _0606_/Y _0607_/Y _1193_/B1 VGND VGND VPWR VPWR _1475_/D sky130_fd_sc_hd__a21oi_1
XFILLER_17_223 VGND VGND VPWR VPWR sky130_fd_sc_hd__fill_1
XFILLER_27_82 VGND VGND VPWR VPWR sky130_fd_sc_hd__decap_12
XFILLER_17_289 VGND VGND VPWR VPWR sky130_fd_sc_hd__decap_3
X_0890_ _0890_/A _0890_/B VGND VGND VPWR VPWR _0891_/B sky130_fd_sc_hd__nor2_1
XTAP_TAPCELL_ROW_27_262 VGND VPWR sky130_fd_sc_hd__tapvpwrvgnd_1
X_1442_ _1469_/CLK _1442_/D _1455_/DE VGND VGND VPWR VPWR _1442_/Q sky130_fd_sc_hd__edfxtp_1
XTAP_TAPCELL_ROW_10_151 VGND VPWR sky130_fd_sc_hd__tapvpwrvgnd_1
X_1373_ clkload3/A _1421_/D _0634_/B VGND VGND VPWR VPWR _1373_/Q sky130_fd_sc_hd__edfxtp_1
XFILLER_13_51 VGND VGND VPWR VPWR sky130_fd_sc_hd__decap_4
Xfanout30 _0754_/Y VGND VGND VPWR VPWR _1407_/DE sky130_fd_sc_hd__clkdlybuf4s50_1
Xfanout96 _1476_/Q VGND VGND VPWR VPWR _1444_/D sky130_fd_sc_hd__clkdlybuf4s50_1
Xfanout85 _1417_/D VGND VGND VPWR VPWR _1449_/D sky130_fd_sc_hd__clkdlybuf4s50_1
Xfanout74 _1487_/Q VGND VGND VPWR VPWR _1455_/D sky130_fd_sc_hd__clkdlybuf4s50_1
Xfanout63 _1492_/Q VGND VGND VPWR VPWR _1093_/A sky130_fd_sc_hd__clkdlybuf4s50_1
Xfanout52 _0621_/Y VGND VGND VPWR VPWR _0629_/B sky130_fd_sc_hd__clkdlybuf4s50_1
Xfanout41 _0644_/Y VGND VGND VPWR VPWR _1434_/DE sky130_fd_sc_hd__clkdlybuf4s50_1
XTAP_TAPCELL_ROW_24_243 VGND VPWR sky130_fd_sc_hd__tapvpwrvgnd_1
XFILLER_1_163 VGND VGND VPWR VPWR sky130_fd_sc_hd__fill_2
XTAP_TAPCELL_ROW_0_87 VGND VPWR sky130_fd_sc_hd__tapvpwrvgnd_1
XFILLER_13_281 VGND VGND VPWR VPWR sky130_fd_sc_hd__decap_8
Xclkload11 _1468_/CLK VGND VGND VPWR VPWR clkload11/X sky130_fd_sc_hd__clkbuf_1
X_0942_ _1145_/A _0716_/B _0941_/Y VGND VGND VPWR VPWR _0944_/C sky130_fd_sc_hd__a21oi_1
X_0873_ _0873_/A _0873_/B VGND VGND VPWR VPWR _0874_/B sky130_fd_sc_hd__nand2_1
XFILLER_9_274 VGND VGND VPWR VPWR sky130_fd_sc_hd__decap_6
X_1425_ _1456_/CLK _1441_/D _1437_/DE VGND VGND VPWR VPWR _1425_/Q sky130_fd_sc_hd__edfxtp_1
X_1287_ clkload9/A _1447_/D _1295_/DE VGND VGND VPWR VPWR _1287_/Q sky130_fd_sc_hd__edfxtp_1
X_1356_ clkload2/A _1420_/D _1357_/DE VGND VGND VPWR VPWR _1356_/Q sky130_fd_sc_hd__edfxtp_1
XTAP_TAPCELL_ROW_38_335 VGND VPWR sky130_fd_sc_hd__tapvpwrvgnd_1
XFILLER_34_39 VGND VGND VPWR VPWR sky130_fd_sc_hd__fill_1
Xclkload5 clkload5/A VGND VGND VPWR VPWR clkload5/X sky130_fd_sc_hd__clkbuf_16
XTAP_TAPCELL_ROW_21_224 VGND VPWR sky130_fd_sc_hd__tapvpwrvgnd_1
XFILLER_10_251 VGND VGND VPWR VPWR sky130_fd_sc_hd__fill_1
XFILLER_6_233 VGND VGND VPWR VPWR sky130_fd_sc_hd__decap_12
XFILLER_6_277 VGND VGND VPWR VPWR sky130_fd_sc_hd__decap_6
XFILLER_18_351 VGND VGND VPWR VPWR sky130_fd_sc_hd__fill_2
XFILLER_1_54 VGND VGND VPWR VPWR sky130_fd_sc_hd__fill_2
XFILLER_1_87 VGND VGND VPWR VPWR sky130_fd_sc_hd__fill_1
XFILLER_37_159 VGND VGND VPWR VPWR sky130_fd_sc_hd__fill_1
X_1210_ clkload5/A _1418_/D _1212_/DE VGND VGND VPWR VPWR _1210_/Q sky130_fd_sc_hd__edfxtp_1
X_1141_ _1141_/A _1141_/B VGND VGND VPWR VPWR _1143_/A sky130_fd_sc_hd__nand2_1
X_1072_ _1069_/Y _1070_/Y _1071_/Y VGND VGND VPWR VPWR _1073_/C sky130_fd_sc_hd__o21ai_1
XFILLER_18_373 VGND VGND VPWR VPWR sky130_fd_sc_hd__fill_1
XFILLER_33_332 VGND VGND VPWR VPWR sky130_fd_sc_hd__fill_1
XFILLER_33_376 VGND VGND VPWR VPWR sky130_fd_sc_hd__fill_2
XTAP_TAPCELL_ROW_35_316 VGND VPWR sky130_fd_sc_hd__tapvpwrvgnd_1
XFILLER_20_19 VGND VGND VPWR VPWR sky130_fd_sc_hd__fill_1
X_0925_ _1089_/A _1229_/Q VGND VGND VPWR VPWR _0927_/A sky130_fd_sc_hd__nand2_1
X_0856_ _1138_/B _1139_/B _1140_/B _1141_/B VGND VGND VPWR VPWR _0857_/B sky130_fd_sc_hd__o22ai_1
X_0787_ _1042_/A _0787_/B VGND VGND VPWR VPWR _0787_/Y sky130_fd_sc_hd__nor2_1
X_1408_ clkload7/A _1408_/D _1423_/DE VGND VGND VPWR VPWR _1408_/Q sky130_fd_sc_hd__edfxtp_1
X_1339_ clkload4/A _1419_/D _0638_/B VGND VGND VPWR VPWR _1339_/Q sky130_fd_sc_hd__edfxtp_1
XFILLER_24_365 VGND VGND VPWR VPWR sky130_fd_sc_hd__decap_12
XPHY_EDGE_ROW_7_Left_47 VGND VGND VPWR VPWR sky130_fd_sc_hd__decap_3
XFILLER_10_85 VGND VGND VPWR VPWR sky130_fd_sc_hd__fill_1
XFILLER_3_214 VGND VGND VPWR VPWR sky130_fd_sc_hd__decap_8
X_0710_ _0710_/A _0931_/A VGND VGND VPWR VPWR _0776_/B sky130_fd_sc_hd__nand2_1
X_0641_ _0641_/A _0641_/B VGND VGND VPWR VPWR _0642_/B sky130_fd_sc_hd__nor2_1
XFILLER_25_3 VGND VGND VPWR VPWR sky130_fd_sc_hd__decap_8
XFILLER_18_192 VGND VGND VPWR VPWR sky130_fd_sc_hd__fill_1
XFILLER_25_129 VGND VGND VPWR VPWR sky130_fd_sc_hd__decap_8
X_1124_ _1124_/A _1124_/B VGND VGND VPWR VPWR _1125_/A sky130_fd_sc_hd__nand2_1
X_1055_ _1055_/A _1055_/B _1055_/C _1055_/D VGND VGND VPWR VPWR _1062_/A sky130_fd_sc_hd__nand4_1
XFILLER_33_184 VGND VGND VPWR VPWR sky130_fd_sc_hd__decap_3
Xoutput18 _1130_/Y VGND VGND VPWR VPWR match_valid sky130_fd_sc_hd__buf_2
X_0908_ _0908_/A _1222_/Q VGND VGND VPWR VPWR _0910_/B sky130_fd_sc_hd__nand2_1
X_0839_ _1092_/A _1385_/Q VGND VGND VPWR VPWR _0841_/A sky130_fd_sc_hd__nand2_1
XFILLER_12_302 VGND VGND VPWR VPWR sky130_fd_sc_hd__decap_3
XFILLER_24_195 VGND VGND VPWR VPWR sky130_fd_sc_hd__fill_1
XFILLER_12_346 VGND VGND VPWR VPWR sky130_fd_sc_hd__fill_2
XFILLER_21_51 VGND VGND VPWR VPWR sky130_fd_sc_hd__fill_1
XFILLER_15_162 VGND VGND VPWR VPWR sky130_fd_sc_hd__decap_6
X_0624_ _1178_/Y _0776_/B VGND VGND VPWR VPWR _0624_/Y sky130_fd_sc_hd__nor2_1
X_1107_ _1246_/Q _1107_/B VGND VGND VPWR VPWR _1108_/B sky130_fd_sc_hd__nand2_1
X_1038_ _1136_/B _1137_/B VGND VGND VPWR VPWR _1148_/A sky130_fd_sc_hd__nand2_1
XPHY_EDGE_ROW_5_Right_5 VGND VGND VPWR VPWR sky130_fd_sc_hd__decap_3
XTAP_TAPCELL_ROW_16_190 VGND VPWR sky130_fd_sc_hd__tapvpwrvgnd_1
XFILLER_12_165 VGND VGND VPWR VPWR sky130_fd_sc_hd__decap_3
XFILLER_32_83 VGND VGND VPWR VPWR sky130_fd_sc_hd__fill_1
XFILLER_35_279 VGND VGND VPWR VPWR sky130_fd_sc_hd__fill_1
XTAP_TAPCELL_ROW_13_171 VGND VPWR sky130_fd_sc_hd__tapvpwrvgnd_1
Xclkbuf_leaf_7_clk clkload0/A VGND VGND VPWR VPWR _1466_/CLK sky130_fd_sc_hd__clkbuf_16
Xhold125 _1457_/Q VGND VGND VPWR VPWR hold125/X sky130_fd_sc_hd__dlygate4sd3_1
Xhold114 _1467_/Q VGND VGND VPWR VPWR _0629_/A sky130_fd_sc_hd__dlygate4sd3_1
X_0607_ _1198_/A _1411_/D VGND VGND VPWR VPWR _0607_/Y sky130_fd_sc_hd__nand2_1
XPHY_EDGE_ROW_36_Left_76 VGND VGND VPWR VPWR sky130_fd_sc_hd__decap_3
XFILLER_17_279 VGND VGND VPWR VPWR sky130_fd_sc_hd__fill_1
XFILLER_27_94 VGND VGND VPWR VPWR sky130_fd_sc_hd__decap_8
XFILLER_32_227 VGND VGND VPWR VPWR sky130_fd_sc_hd__fill_1
XTAP_TAPCELL_ROW_27_263 VGND VPWR sky130_fd_sc_hd__tapvpwrvgnd_1
X_1441_ _1456_/CLK _1441_/D _1453_/DE VGND VGND VPWR VPWR _1441_/Q sky130_fd_sc_hd__edfxtp_1
XTAP_TAPCELL_ROW_10_152 VGND VPWR sky130_fd_sc_hd__tapvpwrvgnd_1
X_1372_ clkload3/A _1420_/D _0634_/B VGND VGND VPWR VPWR _1372_/Q sky130_fd_sc_hd__edfxtp_1
Xfanout20 _1042_/Y VGND VGND VPWR VPWR _1231_/DE sky130_fd_sc_hd__clkdlybuf4s50_1
Xfanout31 _1247_/DE VGND VGND VPWR VPWR _0613_/A sky130_fd_sc_hd__clkdlybuf4s50_1
Xfanout97 _1475_/Q VGND VGND VPWR VPWR _1411_/D sky130_fd_sc_hd__clkdlybuf4s50_1
Xfanout86 _1481_/Q VGND VGND VPWR VPWR _1417_/D sky130_fd_sc_hd__clkdlybuf4s50_1
Xfanout75 _1486_/Q VGND VGND VPWR VPWR _1422_/D sky130_fd_sc_hd__clkdlybuf4s50_1
Xfanout64 _1492_/Q VGND VGND VPWR VPWR _1046_/A sky130_fd_sc_hd__clkdlybuf4s50_1
Xfanout53 _1263_/DE VGND VGND VPWR VPWR _1259_/DE sky130_fd_sc_hd__clkdlybuf4s50_1
XTAP_TAPCELL_ROW_24_244 VGND VPWR sky130_fd_sc_hd__tapvpwrvgnd_1
XFILLER_1_175 VGND VGND VPWR VPWR sky130_fd_sc_hd__decap_12
XFILLER_37_308 VGND VGND VPWR VPWR sky130_fd_sc_hd__decap_4
XTAP_TAPCELL_ROW_0_88 VGND VPWR sky130_fd_sc_hd__tapvpwrvgnd_1
X_0941_ _1128_/B _1128_/C _1144_/B _1143_/B VGND VGND VPWR VPWR _0941_/Y sky130_fd_sc_hd__o22ai_1
Xclkload12 _1459_/CLK VGND VGND VPWR VPWR clkload12/Y sky130_fd_sc_hd__clkinv_2
X_0872_ _1207_/Q _1206_/Q VGND VGND VPWR VPWR _0873_/B sky130_fd_sc_hd__nand2_1
XFILLER_9_231 VGND VGND VPWR VPWR sky130_fd_sc_hd__fill_1
X_1355_ clkload2/A _1419_/D _1357_/DE VGND VGND VPWR VPWR _1355_/Q sky130_fd_sc_hd__edfxtp_1
X_1424_ _1456_/CLK _1440_/D _1437_/DE VGND VGND VPWR VPWR _1424_/Q sky130_fd_sc_hd__edfxtp_1
X_1286_ _1466_/CLK _1446_/D _0631_/B VGND VGND VPWR VPWR _1286_/Q sky130_fd_sc_hd__edfxtp_1
XTAP_TAPCELL_ROW_38_336 VGND VPWR sky130_fd_sc_hd__tapvpwrvgnd_1
XFILLER_11_219 VGND VGND VPWR VPWR sky130_fd_sc_hd__decap_4
Xclkload6 clkload6/A VGND VGND VPWR VPWR clkload6/Y sky130_fd_sc_hd__bufinv_8
XTAP_TAPCELL_ROW_21_225 VGND VPWR sky130_fd_sc_hd__tapvpwrvgnd_1
XFILLER_24_51 VGND VGND VPWR VPWR sky130_fd_sc_hd__fill_1
XFILLER_6_245 VGND VGND VPWR VPWR sky130_fd_sc_hd__decap_6
XFILLER_18_363 VGND VGND VPWR VPWR sky130_fd_sc_hd__fill_1
XFILLER_1_11 VGND VGND VPWR VPWR sky130_fd_sc_hd__decap_3
X_1140_ _1140_/A _1140_/B VGND VGND VPWR VPWR _1141_/A sky130_fd_sc_hd__nand2_1
X_1071_ _1076_/X _1255_/Q VGND VGND VPWR VPWR _1071_/Y sky130_fd_sc_hd__nand2_1
XTAP_TAPCELL_ROW_35_317 VGND VPWR sky130_fd_sc_hd__tapvpwrvgnd_1
XFILLER_33_322 VGND VGND VPWR VPWR sky130_fd_sc_hd__fill_1
X_0924_ _0924_/A _0924_/B VGND VGND VPWR VPWR _0928_/A sky130_fd_sc_hd__nand2_1
XPHY_EDGE_ROW_23_Left_63 VGND VGND VPWR VPWR sky130_fd_sc_hd__decap_3
X_0855_ _0855_/A _0855_/B _0855_/C _0855_/D VGND VGND VPWR VPWR _1141_/B sky130_fd_sc_hd__nand4_2
X_0786_ _0786_/A _0786_/B _0786_/C _0786_/D VGND VGND VPWR VPWR _1138_/B sky130_fd_sc_hd__nand4_2
X_1338_ clkload4/A _1418_/D _0638_/B VGND VGND VPWR VPWR _1338_/Q sky130_fd_sc_hd__edfxtp_1
X_1407_ _1459_/CLK _1455_/D _1407_/DE VGND VGND VPWR VPWR _1407_/Q sky130_fd_sc_hd__edfxtp_1
XFILLER_24_377 VGND VGND VPWR VPWR sky130_fd_sc_hd__fill_1
X_1269_ _1468_/CLK _1445_/D _0629_/B VGND VGND VPWR VPWR _1269_/Q sky130_fd_sc_hd__edfxtp_1
X_0640_ _0776_/A _1042_/B VGND VGND VPWR VPWR _0640_/Y sky130_fd_sc_hd__nor2_2
XFILLER_18_3 VGND VGND VPWR VPWR sky130_fd_sc_hd__fill_1
X_1123_ _1127_/A _1112_/Y _1122_/Y VGND VGND VPWR VPWR _1124_/B sky130_fd_sc_hd__o21ai_1
X_1054_ _1043_/B _1053_/A _1193_/B1 _1043_/Y VGND VGND VPWR VPWR _1488_/D sky130_fd_sc_hd__a211oi_2
X_0907_ _0907_/A _0907_/B VGND VGND VPWR VPWR _0914_/A sky130_fd_sc_hd__nor2_1
Xoutput19 _1126_/Y VGND VGND VPWR VPWR multi_match sky130_fd_sc_hd__buf_2
X_0838_ _0838_/A VGND VGND VPWR VPWR _0838_/Y sky130_fd_sc_hd__inv_1
X_0769_ _1053_/A _1329_/Q VGND VGND VPWR VPWR _0772_/B sky130_fd_sc_hd__nand2_1
XFILLER_24_130 VGND VGND VPWR VPWR sky130_fd_sc_hd__fill_2
XFILLER_8_329 VGND VGND VPWR VPWR sky130_fd_sc_hd__fill_2
XFILLER_15_152 VGND VGND VPWR VPWR sky130_fd_sc_hd__decap_6
X_0623_ _0623_/A VGND VGND VPWR VPWR _1470_/D sky130_fd_sc_hd__buf_2
XFILLER_7_65 VGND VGND VPWR VPWR sky130_fd_sc_hd__fill_1
X_1106_ _1106_/A _1247_/Q VGND VGND VPWR VPWR _1108_/A sky130_fd_sc_hd__nand2_1
X_1037_ _1037_/A _1037_/B _1037_/C _1037_/D VGND VGND VPWR VPWR _1136_/B sky130_fd_sc_hd__nand4_2
XTAP_TAPCELL_ROW_16_191 VGND VPWR sky130_fd_sc_hd__tapvpwrvgnd_1
XFILLER_21_166 VGND VGND VPWR VPWR sky130_fd_sc_hd__fill_2
XPHY_EDGE_ROW_10_Left_50 VGND VGND VPWR VPWR sky130_fd_sc_hd__decap_3
XFILLER_29_277 VGND VGND VPWR VPWR sky130_fd_sc_hd__decap_3
XPHY_EDGE_ROW_11_Right_11 VGND VGND VPWR VPWR sky130_fd_sc_hd__decap_3
XFILLER_8_159 VGND VGND VPWR VPWR sky130_fd_sc_hd__fill_1
XFILLER_8_104 VGND VGND VPWR VPWR sky130_fd_sc_hd__fill_2
XPHY_EDGE_ROW_20_Right_20 VGND VGND VPWR VPWR sky130_fd_sc_hd__decap_3
Xhold115 _1466_/Q VGND VGND VPWR VPWR _0631_/A sky130_fd_sc_hd__dlygate4sd3_1
XTAP_TAPCELL_ROW_13_172 VGND VPWR sky130_fd_sc_hd__tapvpwrvgnd_1
X_0606_ _1197_/A input8/X VGND VGND VPWR VPWR _0606_/Y sky130_fd_sc_hd__nand2_1
XFILLER_17_225 VGND VGND VPWR VPWR sky130_fd_sc_hd__decap_3
XTAP_TAPCELL_ROW_27_264 VGND VPWR sky130_fd_sc_hd__tapvpwrvgnd_1
XTAP_TAPCELL_ROW_10_153 VGND VPWR sky130_fd_sc_hd__tapvpwrvgnd_1
X_1371_ clkload8/A _1419_/D _0634_/B VGND VGND VPWR VPWR _1371_/Q sky130_fd_sc_hd__edfxtp_1
X_1440_ _1456_/CLK _1440_/D _1453_/DE VGND VGND VPWR VPWR _1440_/Q sky130_fd_sc_hd__edfxtp_1
XFILLER_4_88 VGND VGND VPWR VPWR sky130_fd_sc_hd__decap_8
Xfanout21 _1042_/Y VGND VGND VPWR VPWR _1229_/DE sky130_fd_sc_hd__clkdlybuf4s50_1
XFILLER_22_250 VGND VGND VPWR VPWR sky130_fd_sc_hd__fill_2
XFILLER_22_261 VGND VGND VPWR VPWR sky130_fd_sc_hd__decap_3
Xfanout32 _0721_/Y VGND VGND VPWR VPWR _1247_/DE sky130_fd_sc_hd__clkdlybuf4s50_1
Xfanout98 _1475_/Q VGND VGND VPWR VPWR _1443_/D sky130_fd_sc_hd__clkdlybuf4s50_1
Xfanout87 _1416_/D VGND VGND VPWR VPWR _1448_/D sky130_fd_sc_hd__clkdlybuf4s50_1
Xfanout76 _1486_/Q VGND VGND VPWR VPWR _1454_/D sky130_fd_sc_hd__clkdlybuf4s50_1
Xfanout65 _1491_/Q VGND VGND VPWR VPWR _0908_/A sky130_fd_sc_hd__clkdlybuf4s50_1
Xfanout54 _0616_/Y VGND VGND VPWR VPWR _1263_/DE sky130_fd_sc_hd__clkdlybuf4s50_1
Xfanout43 _0644_/Y VGND VGND VPWR VPWR _1439_/DE sky130_fd_sc_hd__clkdlybuf4s50_1
XTAP_TAPCELL_ROW_24_245 VGND VPWR sky130_fd_sc_hd__tapvpwrvgnd_1
XTAP_TAPCELL_ROW_0_89 VGND VPWR sky130_fd_sc_hd__tapvpwrvgnd_1
XFILLER_1_187 VGND VGND VPWR VPWR sky130_fd_sc_hd__decap_8
X_0940_ _0940_/A VGND VGND VPWR VPWR _1128_/C sky130_fd_sc_hd__inv_1
Xclkload13 _1456_/CLK VGND VGND VPWR VPWR clkload13/X sky130_fd_sc_hd__clkbuf_1
X_0871_ _1092_/A _1209_/Q VGND VGND VPWR VPWR _0873_/A sky130_fd_sc_hd__nand2_1
XFILLER_9_287 VGND VGND VPWR VPWR sky130_fd_sc_hd__fill_1
X_1285_ _1466_/CLK _1445_/D _0631_/B VGND VGND VPWR VPWR _1285_/Q sky130_fd_sc_hd__edfxtp_1
X_1354_ clkload2/A _1418_/D _1357_/DE VGND VGND VPWR VPWR _1354_/Q sky130_fd_sc_hd__edfxtp_1
X_1423_ clkload7/A _1423_/D _1423_/DE VGND VGND VPWR VPWR _1423_/Q sky130_fd_sc_hd__edfxtp_1
XTAP_TAPCELL_ROW_38_337 VGND VPWR sky130_fd_sc_hd__tapvpwrvgnd_1
Xclkload7 clkload7/A VGND VGND VPWR VPWR clkload7/Y sky130_fd_sc_hd__inv_8
XTAP_TAPCELL_ROW_21_226 VGND VPWR sky130_fd_sc_hd__tapvpwrvgnd_1
XFILLER_24_85 VGND VGND VPWR VPWR sky130_fd_sc_hd__decap_8
XFILLER_10_231 VGND VGND VPWR VPWR sky130_fd_sc_hd__decap_12
X_1070_ _1260_/Q _1070_/B VGND VGND VPWR VPWR _1070_/Y sky130_fd_sc_hd__nor2_1
XTAP_TAPCELL_ROW_35_318 VGND VPWR sky130_fd_sc_hd__tapvpwrvgnd_1
X_0923_ _0923_/A _1230_/Q VGND VGND VPWR VPWR _0924_/B sky130_fd_sc_hd__nand2_1
X_0854_ _0934_/A VGND VGND VPWR VPWR _1063_/A sky130_fd_sc_hd__buf_6
X_0785_ _0781_/Y _0782_/Y _0783_/Y _0784_/Y VGND VGND VPWR VPWR _0786_/D sky130_fd_sc_hd__o211a_1
X_1337_ clkload8/A _1449_/D _0638_/B VGND VGND VPWR VPWR _1337_/Q sky130_fd_sc_hd__edfxtp_1
X_1406_ _1459_/CLK _1454_/D _1407_/DE VGND VGND VPWR VPWR _1406_/Q sky130_fd_sc_hd__edfxtp_1
X_1268_ _1468_/CLK _1444_/D _0629_/B VGND VGND VPWR VPWR _1268_/Q sky130_fd_sc_hd__edfxtp_1
XFILLER_24_356 VGND VGND VPWR VPWR sky130_fd_sc_hd__decap_8
X_1199_ _1197_/Y _1198_/Y _1199_/B1 VGND VGND VPWR VPWR _1478_/D sky130_fd_sc_hd__a21oi_1
XFILLER_10_98 VGND VGND VPWR VPWR sky130_fd_sc_hd__decap_12
XFILLER_27_172 VGND VGND VPWR VPWR sky130_fd_sc_hd__decap_8
X_1122_ _1128_/C _1128_/B VGND VGND VPWR VPWR _1122_/Y sky130_fd_sc_hd__nand2_1
XFILLER_21_337 VGND VGND VPWR VPWR sky130_fd_sc_hd__decap_4
XFILLER_33_142 VGND VGND VPWR VPWR sky130_fd_sc_hd__fill_2
X_1053_ _1053_/A _1249_/Q VGND VGND VPWR VPWR _1055_/D sky130_fd_sc_hd__nand2_1
X_0906_ _0906_/A _0906_/B VGND VGND VPWR VPWR _0907_/B sky130_fd_sc_hd__nand2_1
X_0837_ _0902_/A _1386_/Q VGND VGND VPWR VPWR _0838_/A sky130_fd_sc_hd__nand2_1
X_0768_ _1076_/X _1335_/Q VGND VGND VPWR VPWR _0772_/A sky130_fd_sc_hd__nand2_1
X_0699_ _0699_/A VGND VGND VPWR VPWR _0715_/C sky130_fd_sc_hd__inv_2
XFILLER_12_315 VGND VGND VPWR VPWR sky130_fd_sc_hd__decap_6
XFILLER_24_153 VGND VGND VPWR VPWR sky130_fd_sc_hd__decap_12
XFILLER_24_175 VGND VGND VPWR VPWR sky130_fd_sc_hd__decap_8
XFILLER_24_197 VGND VGND VPWR VPWR sky130_fd_sc_hd__decap_6
XFILLER_30_3 VGND VGND VPWR VPWR sky130_fd_sc_hd__decap_6
X_0622_ hold120/X _1231_/DE _0639_/A VGND VGND VPWR VPWR _0623_/A sky130_fd_sc_hd__o21ba_2
XFILLER_7_99 VGND VGND VPWR VPWR sky130_fd_sc_hd__decap_6
X_1105_ _1105_/A _1105_/B VGND VGND VPWR VPWR _1110_/A sky130_fd_sc_hd__nand2_1
XFILLER_21_123 VGND VGND VPWR VPWR sky130_fd_sc_hd__decap_8
X_1036_ _1032_/Y _1033_/Y _1034_/Y _1035_/Y VGND VGND VPWR VPWR _1037_/D sky130_fd_sc_hd__o211a_1
XTAP_TAPCELL_ROW_16_192 VGND VPWR sky130_fd_sc_hd__tapvpwrvgnd_1
XTAP_TAPCELL_ROW_8_138 VGND VPWR sky130_fd_sc_hd__tapvpwrvgnd_1
XFILLER_16_53 VGND VGND VPWR VPWR sky130_fd_sc_hd__decap_6
XFILLER_12_112 VGND VGND VPWR VPWR sky130_fd_sc_hd__decap_3
XFILLER_32_85 VGND VGND VPWR VPWR sky130_fd_sc_hd__decap_12
Xhold116 _1465_/Q VGND VGND VPWR VPWR _0625_/A sky130_fd_sc_hd__dlygate4sd3_1
XTAP_TAPCELL_ROW_13_173 VGND VPWR sky130_fd_sc_hd__tapvpwrvgnd_1
X_0605_ _0603_/Y _0604_/Y _1193_/B1 VGND VGND VPWR VPWR _1472_/D sky130_fd_sc_hd__a21oi_1
XTAP_TAPCELL_ROW_5_119 VGND VPWR sky130_fd_sc_hd__tapvpwrvgnd_1
X_1019_ _1053_/A _1297_/Q VGND VGND VPWR VPWR _1023_/B sky130_fd_sc_hd__nand2_1
XFILLER_34_281 VGND VGND VPWR VPWR sky130_fd_sc_hd__decap_3
XFILLER_27_52 VGND VGND VPWR VPWR sky130_fd_sc_hd__fill_1
XTAP_TAPCELL_ROW_27_265 VGND VPWR sky130_fd_sc_hd__tapvpwrvgnd_1
XFILLER_4_141 VGND VGND VPWR VPWR sky130_fd_sc_hd__decap_12
XTAP_TAPCELL_ROW_10_154 VGND VPWR sky130_fd_sc_hd__tapvpwrvgnd_1
X_1370_ clkload3/A _1418_/D _0634_/B VGND VGND VPWR VPWR _1370_/Q sky130_fd_sc_hd__edfxtp_1
Xfanout33 _1389_/DE VGND VGND VPWR VPWR _1391_/DE sky130_fd_sc_hd__clkdlybuf4s50_1
Xfanout55 _1060_/B VGND VGND VPWR VPWR _0923_/A sky130_fd_sc_hd__clkdlybuf4s50_1
Xfanout44 _0640_/Y VGND VGND VPWR VPWR _0641_/B sky130_fd_sc_hd__clkdlybuf4s50_1
XTAP_TAPCELL_ROW_24_246 VGND VPWR sky130_fd_sc_hd__tapvpwrvgnd_1
Xfanout99 _1474_/Q VGND VGND VPWR VPWR _1410_/D sky130_fd_sc_hd__clkdlybuf4s50_1
Xfanout88 _1480_/Q VGND VGND VPWR VPWR _1416_/D sky130_fd_sc_hd__clkdlybuf4s50_1
Xfanout77 _1485_/Q VGND VGND VPWR VPWR _1421_/D sky130_fd_sc_hd__clkdlybuf4s50_1
Xfanout66 _1491_/Q VGND VGND VPWR VPWR _1083_/A sky130_fd_sc_hd__clkdlybuf4s50_1
XFILLER_8_3 VGND VGND VPWR VPWR sky130_fd_sc_hd__fill_1
X_0870_ _1080_/A _0870_/B VGND VGND VPWR VPWR _0874_/A sky130_fd_sc_hd__nor2_1
X_1422_ clkload7/A _1422_/D _1423_/DE VGND VGND VPWR VPWR _1422_/Q sky130_fd_sc_hd__edfxtp_1
X_1284_ _1466_/CLK _1444_/D _0631_/B VGND VGND VPWR VPWR _1284_/Q sky130_fd_sc_hd__edfxtp_1
X_1353_ clkload3/A _1417_/D _1357_/DE VGND VGND VPWR VPWR _1353_/Q sky130_fd_sc_hd__edfxtp_1
XTAP_TAPCELL_ROW_38_338 VGND VPWR sky130_fd_sc_hd__tapvpwrvgnd_1
Xclkload8 clkload8/A VGND VGND VPWR VPWR clkload8/X sky130_fd_sc_hd__clkbuf_1
X_0999_ _1120_/X _1285_/Q VGND VGND VPWR VPWR _1000_/A sky130_fd_sc_hd__nand2_1
XTAP_TAPCELL_ROW_21_227 VGND VPWR sky130_fd_sc_hd__tapvpwrvgnd_1
XFILLER_27_332 VGND VGND VPWR VPWR sky130_fd_sc_hd__fill_1
XFILLER_10_243 VGND VGND VPWR VPWR sky130_fd_sc_hd__decap_8
XFILLER_6_203 VGND VGND VPWR VPWR sky130_fd_sc_hd__decap_6
XFILLER_18_365 VGND VGND VPWR VPWR sky130_fd_sc_hd__decap_8
XFILLER_1_57 VGND VGND VPWR VPWR sky130_fd_sc_hd__decap_6
XTAP_TAPCELL_ROW_35_319 VGND VPWR sky130_fd_sc_hd__tapvpwrvgnd_1
X_0922_ _1049_/A _1216_/Q VGND VGND VPWR VPWR _0924_/A sky130_fd_sc_hd__nand2_1
X_0853_ _1109_/A _1380_/Q _0943_/X _1379_/Q VGND VGND VPWR VPWR _0855_/D sky130_fd_sc_hd__a22oi_1
X_1405_ clkload2/A _1421_/D _0650_/B VGND VGND VPWR VPWR _1405_/Q sky130_fd_sc_hd__edfxtp_1
X_0784_ _1045_/A _1337_/Q VGND VGND VPWR VPWR _0784_/Y sky130_fd_sc_hd__nand2_1
XFILLER_28_129 VGND VGND VPWR VPWR sky130_fd_sc_hd__decap_3
X_1336_ clkload8/A _1448_/D _0638_/B VGND VGND VPWR VPWR _1336_/Q sky130_fd_sc_hd__edfxtp_1
Xinput1 addr[0] VGND VGND VPWR VPWR input1/X sky130_fd_sc_hd__buf_2
X_1267_ _1459_/CLK _1443_/D _1277_/DE VGND VGND VPWR VPWR _1267_/Q sky130_fd_sc_hd__edfxtp_1
X_1198_ _1198_/A _1414_/D VGND VGND VPWR VPWR _1198_/Y sky130_fd_sc_hd__nand2_1
XFILLER_24_346 VGND VGND VPWR VPWR sky130_fd_sc_hd__fill_2
XFILLER_36_195 VGND VGND VPWR VPWR sky130_fd_sc_hd__fill_1
XFILLER_19_107 VGND VGND VPWR VPWR sky130_fd_sc_hd__decap_4
XFILLER_19_53 VGND VGND VPWR VPWR sky130_fd_sc_hd__decap_3
XFILLER_19_75 VGND VGND VPWR VPWR sky130_fd_sc_hd__fill_1
XFILLER_30_305 VGND VGND VPWR VPWR sky130_fd_sc_hd__decap_3
XFILLER_30_316 VGND VGND VPWR VPWR sky130_fd_sc_hd__decap_3
XFILLER_32_7 VGND VGND VPWR VPWR sky130_fd_sc_hd__fill_2
X_1121_ _1121_/A _1121_/B VGND VGND VPWR VPWR _1127_/A sky130_fd_sc_hd__nor2_4
X_1052_ _1052_/A _1052_/B VGND VGND VPWR VPWR _1055_/C sky130_fd_sc_hd__and2_1
XFILLER_33_176 VGND VGND VPWR VPWR sky130_fd_sc_hd__decap_8
X_0905_ _1109_/A _1220_/Q VGND VGND VPWR VPWR _0906_/B sky130_fd_sc_hd__nand2_1
X_0836_ _0836_/A _0836_/B VGND VGND VPWR VPWR _0836_/Y sky130_fd_sc_hd__nand2_1
X_0767_ _1463_/Q VGND VGND VPWR VPWR _0767_/Y sky130_fd_sc_hd__inv_1
X_0698_ input2/X _0931_/C VGND VGND VPWR VPWR _0710_/A sky130_fd_sc_hd__nor2_1
X_1319_ clkload9/A _1447_/D _1326_/DE VGND VGND VPWR VPWR _1319_/Q sky130_fd_sc_hd__edfxtp_1
XFILLER_24_165 VGND VGND VPWR VPWR sky130_fd_sc_hd__fill_1
XFILLER_21_87 VGND VGND VPWR VPWR sky130_fd_sc_hd__fill_1
X_0621_ _1178_/Y _0787_/B VGND VGND VPWR VPWR _0621_/Y sky130_fd_sc_hd__nor2_1
XFILLER_23_3 VGND VGND VPWR VPWR sky130_fd_sc_hd__decap_12
XFILLER_38_257 VGND VGND VPWR VPWR sky130_fd_sc_hd__fill_1
X_1104_ _1104_/A _1234_/Q VGND VGND VPWR VPWR _1105_/B sky130_fd_sc_hd__nand2_1
X_1035_ _1045_/A _1305_/Q VGND VGND VPWR VPWR _1035_/Y sky130_fd_sc_hd__nand2_1
XTAP_TAPCELL_ROW_16_193 VGND VPWR sky130_fd_sc_hd__tapvpwrvgnd_1
X_0819_ _1076_/X _1367_/Q VGND VGND VPWR VPWR _0825_/A sky130_fd_sc_hd__nand2_1
XTAP_TAPCELL_ROW_8_139 VGND VPWR sky130_fd_sc_hd__tapvpwrvgnd_1
XFILLER_29_235 VGND VGND VPWR VPWR sky130_fd_sc_hd__fill_2
XFILLER_32_97 VGND VGND VPWR VPWR sky130_fd_sc_hd__fill_2
XFILLER_4_334 VGND VGND VPWR VPWR sky130_fd_sc_hd__decap_6
XTAP_TAPCELL_ROW_13_174 VGND VPWR sky130_fd_sc_hd__tapvpwrvgnd_1
Xhold117 _1459_/Q VGND VGND VPWR VPWR _0650_/A sky130_fd_sc_hd__dlygate4sd3_1
X_0604_ _1198_/A _1408_/D VGND VGND VPWR VPWR _0604_/Y sky130_fd_sc_hd__nand2_1
XPHY_EDGE_ROW_9_Right_9 VGND VGND VPWR VPWR sky130_fd_sc_hd__decap_3
XFILLER_26_205 VGND VGND VPWR VPWR sky130_fd_sc_hd__fill_1
XFILLER_26_227 VGND VGND VPWR VPWR sky130_fd_sc_hd__fill_1
X_1018_ _1076_/X _1303_/Q VGND VGND VPWR VPWR _1023_/A sky130_fd_sc_hd__nand2_1
XFILLER_1_337 VGND VGND VPWR VPWR sky130_fd_sc_hd__fill_2
XTAP_TAPCELL_ROW_27_266 VGND VPWR sky130_fd_sc_hd__tapvpwrvgnd_1
XFILLER_4_153 VGND VGND VPWR VPWR sky130_fd_sc_hd__decap_3
XTAP_TAPCELL_ROW_10_155 VGND VPWR sky130_fd_sc_hd__tapvpwrvgnd_1
XFILLER_4_197 VGND VGND VPWR VPWR sky130_fd_sc_hd__decap_4
XFILLER_16_293 VGND VGND VPWR VPWR sky130_fd_sc_hd__fill_1
XFILLER_23_208 VGND VGND VPWR VPWR sky130_fd_sc_hd__fill_1
Xfanout23 _0787_/Y VGND VGND VPWR VPWR _0619_/B sky130_fd_sc_hd__clkdlybuf4s50_1
Xfanout34 _0687_/Y VGND VGND VPWR VPWR _1389_/DE sky130_fd_sc_hd__clkdlybuf4s50_1
Xfanout89 _1479_/Q VGND VGND VPWR VPWR _1415_/D sky130_fd_sc_hd__clkdlybuf4s50_1
Xfanout78 _1485_/Q VGND VGND VPWR VPWR _1453_/D sky130_fd_sc_hd__clkdlybuf4s50_1
Xfanout67 _1490_/Q VGND VGND VPWR VPWR _1109_/A sky130_fd_sc_hd__clkdlybuf4s50_1
Xfanout56 _1060_/B VGND VGND VPWR VPWR _1026_/A sky130_fd_sc_hd__clkdlybuf4s50_1
Xfanout45 _0640_/Y VGND VGND VPWR VPWR _1357_/DE sky130_fd_sc_hd__clkdlybuf4s50_1
XTAP_TAPCELL_ROW_24_247 VGND VPWR sky130_fd_sc_hd__tapvpwrvgnd_1
XFILLER_13_55 VGND VGND VPWR VPWR sky130_fd_sc_hd__fill_1
XFILLER_38_85 VGND VGND VPWR VPWR sky130_fd_sc_hd__decap_6
X_1421_ clkload7/A _1421_/D _1421_/DE VGND VGND VPWR VPWR _1421_/Q sky130_fd_sc_hd__edfxtp_1
XFILLER_36_300 VGND VGND VPWR VPWR sky130_fd_sc_hd__decap_8
XFILLER_36_333 VGND VGND VPWR VPWR sky130_fd_sc_hd__fill_1
X_1283_ clkload9/A _1443_/D _0631_/B VGND VGND VPWR VPWR _1283_/Q sky130_fd_sc_hd__edfxtp_1
X_1352_ clkload3/A _1416_/D _1357_/DE VGND VGND VPWR VPWR _1352_/Q sky130_fd_sc_hd__edfxtp_1
XTAP_TAPCELL_ROW_38_339 VGND VPWR sky130_fd_sc_hd__tapvpwrvgnd_1
XFILLER_36_377 VGND VGND VPWR VPWR sky130_fd_sc_hd__fill_1
Xclkload9 clkload9/A VGND VGND VPWR VPWR clkload9/Y sky130_fd_sc_hd__clkinv_2
X_0998_ _0998_/A _0998_/B VGND VGND VPWR VPWR _0998_/Y sky130_fd_sc_hd__nor2_1
XTAP_TAPCELL_ROW_21_228 VGND VPWR sky130_fd_sc_hd__tapvpwrvgnd_1
XFILLER_27_377 VGND VGND VPWR VPWR sky130_fd_sc_hd__fill_1
XFILLER_39_193 VGND VGND VPWR VPWR sky130_fd_sc_hd__decap_3
XFILLER_10_277 VGND VGND VPWR VPWR sky130_fd_sc_hd__decap_12
XFILLER_24_76 VGND VGND VPWR VPWR sky130_fd_sc_hd__decap_8
X_0921_ _0921_/A _0921_/B VGND VGND VPWR VPWR _0938_/A sky130_fd_sc_hd__nor2_1
X_0852_ _0932_/A _1378_/Q VGND VGND VPWR VPWR _0855_/C sky130_fd_sc_hd__nand2_1
X_0783_ _1093_/A _1336_/Q VGND VGND VPWR VPWR _0783_/Y sky130_fd_sc_hd__nand2_1
X_1335_ clkload4/A _1447_/D _1343_/DE VGND VGND VPWR VPWR _1335_/Q sky130_fd_sc_hd__edfxtp_1
X_1404_ clkload2/A _1420_/D _0650_/B VGND VGND VPWR VPWR _1404_/Q sky130_fd_sc_hd__edfxtp_1
XFILLER_5_281 VGND VGND VPWR VPWR sky130_fd_sc_hd__decap_8
XFILLER_24_336 VGND VGND VPWR VPWR sky130_fd_sc_hd__decap_3
Xinput2 addr[1] VGND VGND VPWR VPWR input2/X sky130_fd_sc_hd__buf_2
X_1266_ _1459_/CLK _1442_/D _1277_/DE VGND VGND VPWR VPWR _1266_/Q sky130_fd_sc_hd__edfxtp_1
X_1197_ _1197_/A _1408_/D VGND VGND VPWR VPWR _1197_/Y sky130_fd_sc_hd__nand2_1
XFILLER_19_119 VGND VGND VPWR VPWR sky130_fd_sc_hd__fill_1
XFILLER_30_339 VGND VGND VPWR VPWR sky130_fd_sc_hd__fill_1
XFILLER_2_251 VGND VGND VPWR VPWR sky130_fd_sc_hd__fill_1
XPHY_EDGE_ROW_27_Left_67 VGND VGND VPWR VPWR sky130_fd_sc_hd__decap_3
XFILLER_18_141 VGND VGND VPWR VPWR sky130_fd_sc_hd__fill_1
X_1120_ _1120_/A VGND VGND VPWR VPWR _1120_/X sky130_fd_sc_hd__buf_8
X_1051_ _1104_/A _1250_/Q VGND VGND VPWR VPWR _1052_/B sky130_fd_sc_hd__nand2_1
X_0904_ _1092_/A _1225_/Q VGND VGND VPWR VPWR _0906_/A sky130_fd_sc_hd__nand2_1
X_0835_ _0998_/A _1388_/Q VGND VGND VPWR VPWR _0836_/B sky130_fd_sc_hd__nand2_1
X_0766_ _0858_/B _0858_/A VGND VGND VPWR VPWR _0857_/A sky130_fd_sc_hd__nor2_1
X_0697_ _0934_/A _1451_/Q _0696_/Y VGND VGND VPWR VPWR _0699_/A sky130_fd_sc_hd__a21oi_2
X_1318_ clkload9/A _1446_/D _1326_/DE VGND VGND VPWR VPWR _1318_/Q sky130_fd_sc_hd__edfxtp_1
X_1249_ _1468_/CLK _1441_/D _1259_/DE VGND VGND VPWR VPWR _1249_/Q sky130_fd_sc_hd__edfxtp_1
XFILLER_24_188 VGND VGND VPWR VPWR sky130_fd_sc_hd__decap_4
XFILLER_15_111 VGND VGND VPWR VPWR sky130_fd_sc_hd__fill_1
X_0620_ _0639_/A _0620_/B VGND VGND VPWR VPWR _1471_/D sky130_fd_sc_hd__nor2_2
XFILLER_7_57 VGND VGND VPWR VPWR sky130_fd_sc_hd__decap_8
XFILLER_16_3 VGND VGND VPWR VPWR sky130_fd_sc_hd__fill_1
X_1103_ _1103_/A _1236_/Q VGND VGND VPWR VPWR _1105_/A sky130_fd_sc_hd__nand2_1
X_1034_ _1046_/A _1304_/Q VGND VGND VPWR VPWR _1034_/Y sky130_fd_sc_hd__nand2_1
XFILLER_21_158 VGND VGND VPWR VPWR sky130_fd_sc_hd__decap_8
XFILLER_21_169 VGND VGND VPWR VPWR sky130_fd_sc_hd__fill_1
XTAP_TAPCELL_ROW_16_194 VGND VPWR sky130_fd_sc_hd__tapvpwrvgnd_1
X_0818_ _0818_/A _1461_/Q VGND VGND VPWR VPWR _0826_/A sky130_fd_sc_hd__nand2_1
X_0749_ _0908_/A _1414_/Q VGND VGND VPWR VPWR _0750_/D sky130_fd_sc_hd__nand2_1
XFILLER_29_269 VGND VGND VPWR VPWR sky130_fd_sc_hd__decap_8
XTAP_TAPCELL_ROW_13_175 VGND VPWR sky130_fd_sc_hd__tapvpwrvgnd_1
Xhold118 _1469_/Q VGND VGND VPWR VPWR _0614_/A sky130_fd_sc_hd__dlygate4sd3_1
X_0603_ _1197_/A input5/X VGND VGND VPWR VPWR _0603_/Y sky130_fd_sc_hd__nand2_1
XFILLER_34_261 VGND VGND VPWR VPWR sky130_fd_sc_hd__decap_12
X_1017_ _1465_/Q VGND VGND VPWR VPWR _1017_/Y sky130_fd_sc_hd__inv_1
XPHY_EDGE_ROW_14_Left_54 VGND VGND VPWR VPWR sky130_fd_sc_hd__decap_3
XFILLER_17_217 VGND VGND VPWR VPWR sky130_fd_sc_hd__decap_6
XTAP_TAPCELL_ROW_27_267 VGND VPWR sky130_fd_sc_hd__tapvpwrvgnd_1
XTAP_TAPCELL_ROW_10_156 VGND VPWR sky130_fd_sc_hd__tapvpwrvgnd_1
XFILLER_22_253 VGND VGND VPWR VPWR sky130_fd_sc_hd__decap_8
Xfanout24 _0787_/Y VGND VGND VPWR VPWR _1212_/DE sky130_fd_sc_hd__clkdlybuf4s50_1
Xfanout35 _0654_/Y VGND VGND VPWR VPWR _0638_/B sky130_fd_sc_hd__clkdlybuf4s50_1
Xfanout79 _1484_/Q VGND VGND VPWR VPWR _1420_/D sky130_fd_sc_hd__clkdlybuf4s50_1
Xfanout68 _1490_/Q VGND VGND VPWR VPWR _1103_/A sky130_fd_sc_hd__clkdlybuf4s50_1
Xfanout46 _1295_/DE VGND VGND VPWR VPWR _0631_/B sky130_fd_sc_hd__clkdlybuf4s50_1
XTAP_TAPCELL_ROW_24_248 VGND VPWR sky130_fd_sc_hd__tapvpwrvgnd_1
XFILLER_9_235 VGND VGND VPWR VPWR sky130_fd_sc_hd__decap_3
X_1351_ clkload1/A _1415_/D _0641_/B VGND VGND VPWR VPWR _1351_/Q sky130_fd_sc_hd__edfxtp_1
X_1420_ clkload6/A _1420_/D _1421_/DE VGND VGND VPWR VPWR _1420_/Q sky130_fd_sc_hd__edfxtp_1
X_1282_ _1466_/CLK _1442_/D _0631_/B VGND VGND VPWR VPWR _1282_/Q sky130_fd_sc_hd__edfxtp_1
X_0997_ _1103_/A _1284_/Q _1104_/A _1282_/Q _0996_/Y VGND VGND VPWR VPWR _1015_/A
+ sky130_fd_sc_hd__a221oi_1
XFILLER_5_90 VGND VGND VPWR VPWR sky130_fd_sc_hd__decap_12
XFILLER_24_11 VGND VGND VPWR VPWR sky130_fd_sc_hd__fill_1
XFILLER_10_289 VGND VGND VPWR VPWR sky130_fd_sc_hd__decap_12
XFILLER_33_326 VGND VGND VPWR VPWR sky130_fd_sc_hd__decap_6
X_0920_ _0909_/B _1045_/A _1199_/B1 _0909_/Y VGND VGND VPWR VPWR _1492_/D sky130_fd_sc_hd__a211oi_2
X_0851_ _0851_/A VGND VGND VPWR VPWR _0855_/B sky130_fd_sc_hd__inv_1
X_0782_ _1340_/Q _1070_/B VGND VGND VPWR VPWR _0782_/Y sky130_fd_sc_hd__nor2_1
X_1334_ clkload4/A _1414_/D _1343_/DE VGND VGND VPWR VPWR _1334_/Q sky130_fd_sc_hd__edfxtp_1
X_1403_ clkload5/A _1451_/D _1407_/DE VGND VGND VPWR VPWR _1403_/Q sky130_fd_sc_hd__edfxtp_1
X_1265_ _1468_/CLK _1441_/D _0629_/B VGND VGND VPWR VPWR _1265_/Q sky130_fd_sc_hd__edfxtp_1
XPHY_EDGE_ROW_18_Right_18 VGND VGND VPWR VPWR sky130_fd_sc_hd__decap_3
XFILLER_36_197 VGND VGND VPWR VPWR sky130_fd_sc_hd__decap_8
Xinput3 addr[2] VGND VGND VPWR VPWR input3/X sky130_fd_sc_hd__buf_2
X_1196_ _1194_/Y _1195_/Y _1199_/B1 VGND VGND VPWR VPWR _1479_/D sky130_fd_sc_hd__a21oi_1
XTAP_TAPCELL_ROW_34_310 VGND VPWR sky130_fd_sc_hd__tapvpwrvgnd_1
XPHY_EDGE_ROW_27_Right_27 VGND VGND VPWR VPWR sky130_fd_sc_hd__decap_3
XFILLER_10_57 VGND VGND VPWR VPWR sky130_fd_sc_hd__decap_3
XPHY_EDGE_ROW_36_Right_36 VGND VGND VPWR VPWR sky130_fd_sc_hd__decap_3
XFILLER_15_337 VGND VGND VPWR VPWR sky130_fd_sc_hd__fill_1
XFILLER_35_32 VGND VGND VPWR VPWR sky130_fd_sc_hd__fill_1
XPHY_EDGE_ROW_2_Left_42 VGND VGND VPWR VPWR sky130_fd_sc_hd__decap_3
XFILLER_18_197 VGND VGND VPWR VPWR sky130_fd_sc_hd__fill_1
XFILLER_33_134 VGND VGND VPWR VPWR sky130_fd_sc_hd__decap_8
X_1050_ _1099_/A _1251_/Q VGND VGND VPWR VPWR _1052_/A sky130_fd_sc_hd__nand2_1
X_0903_ _0903_/A _0903_/B VGND VGND VPWR VPWR _0907_/A sky130_fd_sc_hd__nand2_1
X_0834_ _1070_/B _1389_/Q VGND VGND VPWR VPWR _0836_/A sky130_fd_sc_hd__nand2_1
X_0765_ _1178_/Y _0765_/B VGND VGND VPWR VPWR _0765_/Y sky130_fd_sc_hd__nor2_1
X_0696_ _0696_/A _0696_/B VGND VGND VPWR VPWR _0696_/Y sky130_fd_sc_hd__nand2_1
X_1317_ clkload9/A _1445_/D _1326_/DE VGND VGND VPWR VPWR _1317_/Q sky130_fd_sc_hd__edfxtp_1
X_1248_ _1468_/CLK _1408_/D _1259_/DE VGND VGND VPWR VPWR _1248_/Q sky130_fd_sc_hd__edfxtp_1
X_1179_ _1192_/A _1416_/D VGND VGND VPWR VPWR _1179_/Y sky130_fd_sc_hd__nand2_1
XFILLER_15_189 VGND VGND VPWR VPWR sky130_fd_sc_hd__decap_3
XFILLER_7_377 VGND VGND VPWR VPWR sky130_fd_sc_hd__fill_1
X_1102_ _1102_/A _1102_/B VGND VGND VPWR VPWR _1111_/B sky130_fd_sc_hd__nor2_1
X_1033_ _1308_/Q _1070_/B VGND VGND VPWR VPWR _1033_/Y sky130_fd_sc_hd__nor2_1
X_0817_ _1120_/X _1365_/Q VGND VGND VPWR VPWR _0818_/A sky130_fd_sc_hd__nand2_1
XTAP_TAPCELL_ROW_16_195 VGND VPWR sky130_fd_sc_hd__tapvpwrvgnd_1
X_0748_ _1408_/Q _1049_/A VGND VGND VPWR VPWR _0750_/C sky130_fd_sc_hd__nand2_1
X_0679_ _1107_/B _1438_/Q VGND VGND VPWR VPWR _0680_/A sky130_fd_sc_hd__nand2_1
XPHY_EDGE_ROW_0_Right_0 VGND VGND VPWR VPWR sky130_fd_sc_hd__decap_3
XFILLER_32_77 VGND VGND VPWR VPWR sky130_fd_sc_hd__decap_6
XFILLER_4_303 VGND VGND VPWR VPWR sky130_fd_sc_hd__decap_4
XFILLER_4_325 VGND VGND VPWR VPWR sky130_fd_sc_hd__fill_2
XFILLER_28_281 VGND VGND VPWR VPWR sky130_fd_sc_hd__fill_1
XTAP_TAPCELL_ROW_13_176 VGND VPWR sky130_fd_sc_hd__tapvpwrvgnd_1
Xhold119 _1458_/Q VGND VGND VPWR VPWR hold119/X sky130_fd_sc_hd__dlygate4sd3_1
X_0602_ _0600_/Y _0601_/Y _1193_/B1 VGND VGND VPWR VPWR _1473_/D sky130_fd_sc_hd__a21oi_1
XFILLER_7_196 VGND VGND VPWR VPWR sky130_fd_sc_hd__fill_1
XFILLER_19_281 VGND VGND VPWR VPWR sky130_fd_sc_hd__decap_12
XFILLER_34_273 VGND VGND VPWR VPWR sky130_fd_sc_hd__decap_8
X_1016_ _1134_/B _1135_/B VGND VGND VPWR VPWR _1039_/A sky130_fd_sc_hd__nand2_1
XFILLER_25_273 VGND VGND VPWR VPWR sky130_fd_sc_hd__decap_6
XTAP_TAPCELL_ROW_10_157 VGND VPWR sky130_fd_sc_hd__tapvpwrvgnd_1
XFILLER_0_361 VGND VGND VPWR VPWR sky130_fd_sc_hd__decap_3
XPHY_EDGE_ROW_31_Left_71 VGND VGND VPWR VPWR sky130_fd_sc_hd__decap_3
Xclkbuf_leaf_11_clk clkload0/A VGND VGND VPWR VPWR _1456_/CLK sky130_fd_sc_hd__clkbuf_16
XFILLER_39_376 VGND VGND VPWR VPWR sky130_fd_sc_hd__fill_2
XFILLER_13_57 VGND VGND VPWR VPWR sky130_fd_sc_hd__decap_12
Xfanout25 _0776_/Y VGND VGND VPWR VPWR _0634_/B sky130_fd_sc_hd__clkdlybuf4s50_1
Xfanout36 _0654_/Y VGND VGND VPWR VPWR _1343_/DE sky130_fd_sc_hd__clkdlybuf4s50_1
Xfanout69 _1489_/Q VGND VGND VPWR VPWR _0932_/A sky130_fd_sc_hd__clkdlybuf4s50_1
Xfanout58 _1495_/Q VGND VGND VPWR VPWR _1060_/B sky130_fd_sc_hd__clkdlybuf4s50_1
Xfanout47 _0632_/Y VGND VGND VPWR VPWR _1295_/DE sky130_fd_sc_hd__clkdlybuf4s50_1
X_1281_ clkload9/A _1441_/D _0631_/B VGND VGND VPWR VPWR _1281_/Q sky130_fd_sc_hd__edfxtp_1
X_1350_ clkload3/A _1414_/D _0641_/B VGND VGND VPWR VPWR _1350_/Q sky130_fd_sc_hd__edfxtp_1
Xclkbuf_leaf_0_clk clkbuf_leaf_4_clk/A VGND VGND VPWR VPWR clkload1/A sky130_fd_sc_hd__clkbuf_16
X_0996_ _1107_/B _0994_/Y _0995_/Y VGND VGND VPWR VPWR _0996_/Y sky130_fd_sc_hd__o21ai_0
XFILLER_8_280 VGND VGND VPWR VPWR sky130_fd_sc_hd__decap_4
X_1479_ _1494_/CLK _1479_/D VGND VGND VPWR VPWR _1479_/Q sky130_fd_sc_hd__dfxtp_1
XTAP_TAPCELL_ROW_37_330 VGND VPWR sky130_fd_sc_hd__tapvpwrvgnd_1
XFILLER_6_3 VGND VGND VPWR VPWR sky130_fd_sc_hd__fill_1
X_0850_ _0850_/A _1460_/Q _0850_/C _0850_/D VGND VGND VPWR VPWR _0851_/A sky130_fd_sc_hd__nand4_1
X_1402_ clkload5/A _1450_/D _0650_/B VGND VGND VPWR VPWR _1402_/Q sky130_fd_sc_hd__edfxtp_1
X_0781_ _0998_/A _1341_/Q VGND VGND VPWR VPWR _0781_/Y sky130_fd_sc_hd__nor2_1
XFILLER_5_272 VGND VGND VPWR VPWR sky130_fd_sc_hd__decap_8
XFILLER_39_3 VGND VGND VPWR VPWR sky130_fd_sc_hd__decap_12
X_1333_ clkload4/A _1413_/D _1343_/DE VGND VGND VPWR VPWR _1333_/Q sky130_fd_sc_hd__edfxtp_1
Xinput4 addr[3] VGND VGND VPWR VPWR input4/X sky130_fd_sc_hd__buf_2
X_1264_ _1459_/CLK _1440_/D _1277_/DE VGND VGND VPWR VPWR _1264_/Q sky130_fd_sc_hd__edfxtp_1
XFILLER_24_316 VGND VGND VPWR VPWR sky130_fd_sc_hd__decap_12
X_1195_ _1198_/A _1415_/D VGND VGND VPWR VPWR _1195_/Y sky130_fd_sc_hd__nand2_1
XTAP_TAPCELL_ROW_34_311 VGND VPWR sky130_fd_sc_hd__tapvpwrvgnd_1
X_0979_ _1090_/B _1276_/Q VGND VGND VPWR VPWR _0980_/B sky130_fd_sc_hd__nand2_1
XFILLER_15_316 VGND VGND VPWR VPWR sky130_fd_sc_hd__decap_12
XFILLER_19_45 VGND VGND VPWR VPWR sky130_fd_sc_hd__decap_8
XFILLER_35_22 VGND VGND VPWR VPWR sky130_fd_sc_hd__fill_2
XFILLER_15_349 VGND VGND VPWR VPWR sky130_fd_sc_hd__fill_1
XFILLER_35_55 VGND VGND VPWR VPWR sky130_fd_sc_hd__fill_1
XFILLER_18_176 VGND VGND VPWR VPWR sky130_fd_sc_hd__fill_1
X_0902_ _0902_/A _1226_/Q VGND VGND VPWR VPWR _0903_/B sky130_fd_sc_hd__nand2_1
X_0833_ _0833_/A _0833_/B _0833_/C _0833_/D VGND VGND VPWR VPWR _1140_/B sky130_fd_sc_hd__nand4_2
X_0764_ _0764_/A VGND VGND VPWR VPWR _0858_/A sky130_fd_sc_hd__inv_2
X_0695_ _1100_/A _1450_/Q VGND VGND VPWR VPWR _0696_/B sky130_fd_sc_hd__nand2_1
X_1316_ clkload9/A _1444_/D _1326_/DE VGND VGND VPWR VPWR _1316_/Q sky130_fd_sc_hd__edfxtp_1
X_1247_ _1469_/CLK _1423_/D _1247_/DE VGND VGND VPWR VPWR _1247_/Q sky130_fd_sc_hd__edfxtp_1
X_1178_ _1178_/A VGND VGND VPWR VPWR _1178_/Y sky130_fd_sc_hd__inv_1
XFILLER_20_363 VGND VGND VPWR VPWR sky130_fd_sc_hd__fill_1
XFILLER_15_113 VGND VGND VPWR VPWR sky130_fd_sc_hd__fill_1
Xmax_cap22 _1043_/B VGND VGND VPWR VPWR _0909_/B sky130_fd_sc_hd__clkbuf_2
XFILLER_38_205 VGND VGND VPWR VPWR sky130_fd_sc_hd__decap_3
X_1101_ _1101_/A _1101_/B VGND VGND VPWR VPWR _1102_/B sky130_fd_sc_hd__nand2_1
X_1032_ _1090_/B _1309_/Q VGND VGND VPWR VPWR _1032_/Y sky130_fd_sc_hd__nor2_1
XTAP_TAPCELL_ROW_16_196 VGND VPWR sky130_fd_sc_hd__tapvpwrvgnd_1
X_0816_ _1063_/A _1371_/Q _0815_/Y VGND VGND VPWR VPWR _0833_/B sky130_fd_sc_hd__a21oi_1
X_0747_ _1082_/A _1409_/Q VGND VGND VPWR VPWR _0750_/B sky130_fd_sc_hd__nand2_1
X_0678_ _1107_/B VGND VGND VPWR VPWR _1106_/A sky130_fd_sc_hd__inv_8
X_0601_ _1198_/A _1409_/D VGND VGND VPWR VPWR _0601_/Y sky130_fd_sc_hd__nand2_1
XFILLER_21_3 VGND VGND VPWR VPWR sky130_fd_sc_hd__decap_8
XFILLER_19_293 VGND VGND VPWR VPWR sky130_fd_sc_hd__decap_4
X_1015_ _1015_/A _1015_/B _1015_/C _1015_/D VGND VGND VPWR VPWR _1135_/B sky130_fd_sc_hd__nand4_2
XTAP_TAPCELL_ROW_4_112 VGND VPWR sky130_fd_sc_hd__tapvpwrvgnd_1
XTAP_TAPCELL_ROW_18_203 VGND VPWR sky130_fd_sc_hd__tapvpwrvgnd_1
X_1495_ clkload4/A _1495_/D VGND VGND VPWR VPWR _1495_/Q sky130_fd_sc_hd__dfxtp_1
Xfanout26 _0776_/Y VGND VGND VPWR VPWR _1375_/DE sky130_fd_sc_hd__clkdlybuf4s50_1
Xfanout37 _0652_/Y VGND VGND VPWR VPWR _1423_/DE sky130_fd_sc_hd__clkdlybuf4s50_1
Xfanout59 _1494_/Q VGND VGND VPWR VPWR _0998_/A sky130_fd_sc_hd__clkdlybuf4s50_1
Xfanout48 _0624_/Y VGND VGND VPWR VPWR _1304_/DE sky130_fd_sc_hd__clkdlybuf4s50_1
XTAP_TAPCELL_ROW_32_294 VGND VPWR sky130_fd_sc_hd__tapvpwrvgnd_1
XFILLER_1_126 VGND VGND VPWR VPWR sky130_fd_sc_hd__decap_12
XFILLER_38_11 VGND VGND VPWR VPWR sky130_fd_sc_hd__fill_2
XFILLER_13_233 VGND VGND VPWR VPWR sky130_fd_sc_hd__decap_3
X_1280_ clkload9/A _1440_/D _0631_/B VGND VGND VPWR VPWR _1280_/Q sky130_fd_sc_hd__edfxtp_1
X_0995_ _1107_/B _1294_/Q VGND VGND VPWR VPWR _0995_/Y sky130_fd_sc_hd__nand2_1
X_1478_ _1494_/CLK _1478_/D VGND VGND VPWR VPWR _1478_/Q sky130_fd_sc_hd__dfxtp_1
XTAP_TAPCELL_ROW_37_331 VGND VPWR sky130_fd_sc_hd__tapvpwrvgnd_1
XFILLER_24_35 VGND VGND VPWR VPWR sky130_fd_sc_hd__decap_12
XTAP_TAPCELL_ROW_20_220 VGND VPWR sky130_fd_sc_hd__tapvpwrvgnd_1
X_0780_ _1063_/A _1339_/Q _0779_/X VGND VGND VPWR VPWR _0786_/C sky130_fd_sc_hd__a21oi_1
X_1401_ _1459_/CLK _1417_/D _1407_/DE VGND VGND VPWR VPWR _1401_/Q sky130_fd_sc_hd__edfxtp_1
XTAP_TAPCELL_ROW_1_93 VGND VPWR sky130_fd_sc_hd__tapvpwrvgnd_1
X_1332_ clkload4/A _1412_/D _1343_/DE VGND VGND VPWR VPWR _1332_/Q sky130_fd_sc_hd__edfxtp_1
Xinput5 data[0] VGND VGND VPWR VPWR input5/X sky130_fd_sc_hd__buf_2
X_1263_ _1468_/CLK _1423_/D _1263_/DE VGND VGND VPWR VPWR _1263_/Q sky130_fd_sc_hd__edfxtp_1
X_1194_ _1197_/A _1409_/D VGND VGND VPWR VPWR _1194_/Y sky130_fd_sc_hd__nand2_1
XFILLER_24_328 VGND VGND VPWR VPWR sky130_fd_sc_hd__decap_8
XFILLER_32_372 VGND VGND VPWR VPWR sky130_fd_sc_hd__decap_6
XTAP_TAPCELL_ROW_34_312 VGND VPWR sky130_fd_sc_hd__tapvpwrvgnd_1
X_0978_ _1070_/B _1277_/Q VGND VGND VPWR VPWR _0980_/A sky130_fd_sc_hd__nand2_1
XFILLER_15_328 VGND VGND VPWR VPWR sky130_fd_sc_hd__decap_8
XFILLER_19_57 VGND VGND VPWR VPWR sky130_fd_sc_hd__decap_12
XFILLER_30_309 VGND VGND VPWR VPWR sky130_fd_sc_hd__decap_3
XFILLER_18_133 VGND VGND VPWR VPWR sky130_fd_sc_hd__decap_6
XFILLER_18_188 VGND VGND VPWR VPWR sky130_fd_sc_hd__decap_4
X_0901_ _1106_/A _1231_/Q VGND VGND VPWR VPWR _0903_/A sky130_fd_sc_hd__nand2_1
X_0832_ _1131_/B VGND VGND VPWR VPWR _1043_/B sky130_fd_sc_hd__clkbuf_1
X_0763_ _1143_/B _1144_/B VGND VGND VPWR VPWR _0764_/A sky130_fd_sc_hd__nand2_1
X_1315_ clkload9/A _1443_/D _1326_/DE VGND VGND VPWR VPWR _1315_/Q sky130_fd_sc_hd__edfxtp_1
X_0694_ _1099_/A _1443_/Q VGND VGND VPWR VPWR _0696_/A sky130_fd_sc_hd__nand2_1
X_1246_ _1469_/CLK _1422_/D _1247_/DE VGND VGND VPWR VPWR _1246_/Q sky130_fd_sc_hd__edfxtp_1
X_1177_ _1191_/A _1410_/D VGND VGND VPWR VPWR _1177_/Y sky130_fd_sc_hd__nand2_1
XFILLER_30_128 VGND VGND VPWR VPWR sky130_fd_sc_hd__decap_12
X_1100_ _1100_/A _1242_/Q VGND VGND VPWR VPWR _1101_/B sky130_fd_sc_hd__nand2_1
X_1031_ _0909_/B _0943_/X _1193_/B1 _1020_/Y VGND VGND VPWR VPWR _1489_/D sky130_fd_sc_hd__a211oi_2
X_0815_ _0815_/A _0815_/B VGND VGND VPWR VPWR _0815_/Y sky130_fd_sc_hd__nand2_1
X_0746_ _1076_/X _1415_/Q VGND VGND VPWR VPWR _0750_/A sky130_fd_sc_hd__nand2_1
X_0677_ _0677_/A _0677_/B VGND VGND VPWR VPWR _0684_/A sky130_fd_sc_hd__nor2_1
X_1229_ clkload6/A _1421_/D _1229_/DE VGND VGND VPWR VPWR _1229_/Q sky130_fd_sc_hd__edfxtp_1
XFILLER_12_139 VGND VGND VPWR VPWR sky130_fd_sc_hd__fill_1
XTAP_TAPCELL_ROW_7_132 VGND VPWR sky130_fd_sc_hd__tapvpwrvgnd_1
XFILLER_11_161 VGND VGND VPWR VPWR sky130_fd_sc_hd__fill_1
X_0600_ _1197_/A input6/X VGND VGND VPWR VPWR _0600_/Y sky130_fd_sc_hd__nand2_1
XFILLER_14_3 VGND VGND VPWR VPWR sky130_fd_sc_hd__decap_12
XFILLER_26_209 VGND VGND VPWR VPWR sky130_fd_sc_hd__fill_1
X_1014_ _1010_/Y _1011_/Y _1012_/Y _1013_/Y VGND VGND VPWR VPWR _1015_/D sky130_fd_sc_hd__o211a_1
X_0729_ _1106_/A _1407_/Q VGND VGND VPWR VPWR _0733_/A sky130_fd_sc_hd__nand2_1
XFILLER_27_57 VGND VGND VPWR VPWR sky130_fd_sc_hd__fill_1
XTAP_TAPCELL_ROW_4_113 VGND VPWR sky130_fd_sc_hd__tapvpwrvgnd_1
XFILLER_25_264 VGND VGND VPWR VPWR sky130_fd_sc_hd__decap_4
XTAP_TAPCELL_ROW_18_204 VGND VPWR sky130_fd_sc_hd__tapvpwrvgnd_1
XFILLER_31_223 VGND VGND VPWR VPWR sky130_fd_sc_hd__fill_1
XFILLER_31_256 VGND VGND VPWR VPWR sky130_fd_sc_hd__decap_12
X_1494_ _1494_/CLK _1494_/D VGND VGND VPWR VPWR _1494_/Q sky130_fd_sc_hd__dfxtp_1
XPHY_EDGE_ROW_18_Left_58 VGND VGND VPWR VPWR sky130_fd_sc_hd__decap_3
XFILLER_22_212 VGND VGND VPWR VPWR sky130_fd_sc_hd__fill_2
Xfanout27 _1327_/DE VGND VGND VPWR VPWR _1326_/DE sky130_fd_sc_hd__clkdlybuf4s50_1
Xfanout38 _0652_/Y VGND VGND VPWR VPWR _1421_/DE sky130_fd_sc_hd__clkdlybuf4s50_1
XTAP_TAPCELL_ROW_32_295 VGND VPWR sky130_fd_sc_hd__tapvpwrvgnd_1
XFILLER_1_138 VGND VGND VPWR VPWR sky130_fd_sc_hd__fill_1
XFILLER_13_289 VGND VGND VPWR VPWR sky130_fd_sc_hd__decap_3
XTAP_TAPCELL_ROW_23_240 VGND VPWR sky130_fd_sc_hd__tapvpwrvgnd_1
XFILLER_0_182 VGND VGND VPWR VPWR sky130_fd_sc_hd__decap_12
X_0994_ _1295_/Q VGND VGND VPWR VPWR _0994_/Y sky130_fd_sc_hd__inv_1
X_1477_ _1494_/CLK _1477_/D VGND VGND VPWR VPWR _1477_/Q sky130_fd_sc_hd__dfxtp_1
XFILLER_5_60 VGND VGND VPWR VPWR sky130_fd_sc_hd__decap_12
XFILLER_39_120 VGND VGND VPWR VPWR sky130_fd_sc_hd__decap_6
XTAP_TAPCELL_ROW_37_332 VGND VPWR sky130_fd_sc_hd__tapvpwrvgnd_1
XFILLER_24_47 VGND VGND VPWR VPWR sky130_fd_sc_hd__decap_4
XTAP_TAPCELL_ROW_20_221 VGND VPWR sky130_fd_sc_hd__tapvpwrvgnd_1
XFILLER_18_304 VGND VGND VPWR VPWR sky130_fd_sc_hd__decap_4
X_1331_ clkload4/A _1411_/D _0638_/B VGND VGND VPWR VPWR _1331_/Q sky130_fd_sc_hd__edfxtp_1
X_1400_ clkload5/A _1416_/D _1407_/DE VGND VGND VPWR VPWR _1400_/Q sky130_fd_sc_hd__edfxtp_1
XTAP_TAPCELL_ROW_1_94 VGND VPWR sky130_fd_sc_hd__tapvpwrvgnd_1
Xinput6 data[1] VGND VGND VPWR VPWR input6/X sky130_fd_sc_hd__buf_2
X_1262_ _1468_/CLK _1422_/D _1263_/DE VGND VGND VPWR VPWR _1262_/Q sky130_fd_sc_hd__edfxtp_1
X_1193_ _1191_/Y _1192_/Y _1193_/B1 VGND VGND VPWR VPWR _1476_/D sky130_fd_sc_hd__a21oi_1
XFILLER_32_362 VGND VGND VPWR VPWR sky130_fd_sc_hd__fill_2
XTAP_TAPCELL_ROW_34_313 VGND VPWR sky130_fd_sc_hd__tapvpwrvgnd_1
XFILLER_10_27 VGND VGND VPWR VPWR sky130_fd_sc_hd__fill_1
XFILLER_10_49 VGND VGND VPWR VPWR sky130_fd_sc_hd__decap_8
X_0977_ _1083_/A _1270_/Q _0943_/X _1267_/Q _0975_/Y VGND VGND VPWR VPWR _0993_/A
+ sky130_fd_sc_hd__a221oi_2
XFILLER_19_69 VGND VGND VPWR VPWR sky130_fd_sc_hd__decap_6
XFILLER_35_57 VGND VGND VPWR VPWR sky130_fd_sc_hd__decap_12
XPHY_EDGE_ROW_14_Right_14 VGND VGND VPWR VPWR sky130_fd_sc_hd__decap_3
XPHY_EDGE_ROW_23_Right_23 VGND VGND VPWR VPWR sky130_fd_sc_hd__decap_3
X_0900_ _0900_/A _0900_/B VGND VGND VPWR VPWR _1128_/B sky130_fd_sc_hd__nand2_1
XPHY_EDGE_ROW_32_Right_32 VGND VGND VPWR VPWR sky130_fd_sc_hd__decap_3
X_0831_ _0827_/Y _0828_/Y _0829_/Y _0830_/Y VGND VGND VPWR VPWR _0833_/D sky130_fd_sc_hd__o211a_1
X_0762_ _0762_/A _0762_/B _0762_/C _0762_/D VGND VGND VPWR VPWR _1144_/B sky130_fd_sc_hd__nand4_2
X_0693_ _0693_/A _0693_/B _0693_/C _0693_/D VGND VGND VPWR VPWR _0715_/B sky130_fd_sc_hd__nand4_1
X_1314_ clkload8/A _1442_/D _1326_/DE VGND VGND VPWR VPWR _1314_/Q sky130_fd_sc_hd__edfxtp_1
X_1245_ _1456_/CLK _1421_/D _1247_/DE VGND VGND VPWR VPWR _1245_/Q sky130_fd_sc_hd__edfxtp_1
X_1176_ _1174_/Y _1175_/Y _0642_/A VGND VGND VPWR VPWR _1481_/D sky130_fd_sc_hd__a21oi_1
XFILLER_20_321 VGND VGND VPWR VPWR sky130_fd_sc_hd__decap_12
XFILLER_20_365 VGND VGND VPWR VPWR sky130_fd_sc_hd__fill_1
XFILLER_32_181 VGND VGND VPWR VPWR sky130_fd_sc_hd__decap_6
XPHY_EDGE_ROW_6_Left_46 VGND VGND VPWR VPWR sky130_fd_sc_hd__decap_3
XFILLER_7_369 VGND VGND VPWR VPWR sky130_fd_sc_hd__decap_8
X_1030_ _1063_/A _1307_/Q _1029_/X VGND VGND VPWR VPWR _1037_/C sky130_fd_sc_hd__a21oi_1
X_0814_ _0902_/A _1370_/Q VGND VGND VPWR VPWR _0815_/B sky130_fd_sc_hd__nand2_1
X_0745_ _0745_/A _1458_/Q VGND VGND VPWR VPWR _0751_/A sky130_fd_sc_hd__nand2_1
X_0676_ _0676_/A VGND VGND VPWR VPWR _0765_/B sky130_fd_sc_hd__inv_1
X_1228_ clkload6/A _1420_/D _1231_/DE VGND VGND VPWR VPWR _1228_/Q sky130_fd_sc_hd__edfxtp_1
XFILLER_16_59 VGND VGND VPWR VPWR sky130_fd_sc_hd__fill_1
X_1159_ _1197_/A VGND VGND VPWR VPWR _1191_/A sky130_fd_sc_hd__buf_2
XFILLER_32_36 VGND VGND VPWR VPWR sky130_fd_sc_hd__fill_1
XFILLER_32_47 VGND VGND VPWR VPWR sky130_fd_sc_hd__fill_1
XFILLER_32_58 VGND VGND VPWR VPWR sky130_fd_sc_hd__decap_3
XTAP_TAPCELL_ROW_7_133 VGND VPWR sky130_fd_sc_hd__tapvpwrvgnd_1
XFILLER_3_372 VGND VGND VPWR VPWR sky130_fd_sc_hd__decap_6
X_1013_ _1045_/A _1289_/Q VGND VGND VPWR VPWR _1013_/Y sky130_fd_sc_hd__nand2_1
Xclkbuf_leaf_14_clk clkbuf_leaf_4_clk/A VGND VGND VPWR VPWR clkload7/A sky130_fd_sc_hd__clkbuf_16
X_0728_ _0728_/A _0728_/B VGND VGND VPWR VPWR _0734_/A sky130_fd_sc_hd__nand2_1
X_0659_ _1082_/A _1425_/Q VGND VGND VPWR VPWR _0662_/B sky130_fd_sc_hd__nand2_1
XTAP_TAPCELL_ROW_4_114 VGND VPWR sky130_fd_sc_hd__tapvpwrvgnd_1
XPHY_EDGE_ROW_4_Right_4 VGND VGND VPWR VPWR sky130_fd_sc_hd__decap_3
XFILLER_4_29 VGND VGND VPWR VPWR sky130_fd_sc_hd__fill_1
XFILLER_16_221 VGND VGND VPWR VPWR sky130_fd_sc_hd__decap_3
XFILLER_17_91 VGND VGND VPWR VPWR sky130_fd_sc_hd__fill_1
XTAP_TAPCELL_ROW_26_260 VGND VPWR sky130_fd_sc_hd__tapvpwrvgnd_1
XTAP_TAPCELL_ROW_18_205 VGND VPWR sky130_fd_sc_hd__tapvpwrvgnd_1
XFILLER_31_268 VGND VGND VPWR VPWR sky130_fd_sc_hd__decap_4
X_1493_ _1494_/CLK _1493_/D VGND VGND VPWR VPWR _1493_/Q sky130_fd_sc_hd__dfxtp_1
Xclkbuf_leaf_3_clk clkbuf_leaf_4_clk/A VGND VGND VPWR VPWR _1494_/CLK sky130_fd_sc_hd__clkbuf_16
XFILLER_39_313 VGND VGND VPWR VPWR sky130_fd_sc_hd__fill_1
Xfanout28 _0765_/Y VGND VGND VPWR VPWR _1327_/DE sky130_fd_sc_hd__clkdlybuf4s50_1
Xfanout39 _1455_/DE VGND VGND VPWR VPWR _1453_/DE sky130_fd_sc_hd__clkdlybuf4s50_1
XTAP_TAPCELL_ROW_32_296 VGND VPWR sky130_fd_sc_hd__tapvpwrvgnd_1
XFILLER_13_213 VGND VGND VPWR VPWR sky130_fd_sc_hd__decap_4
XFILLER_13_268 VGND VGND VPWR VPWR sky130_fd_sc_hd__decap_12
XTAP_TAPCELL_ROW_23_241 VGND VPWR sky130_fd_sc_hd__tapvpwrvgnd_1
XPHY_EDGE_ROW_35_Left_75 VGND VGND VPWR VPWR sky130_fd_sc_hd__decap_3
XFILLER_0_194 VGND VGND VPWR VPWR sky130_fd_sc_hd__fill_2
X_0993_ _0993_/A _0993_/B _0993_/C _0993_/D VGND VGND VPWR VPWR _1134_/B sky130_fd_sc_hd__nand4_1
X_1476_ _1494_/CLK _1476_/D VGND VGND VPWR VPWR _1476_/Q sky130_fd_sc_hd__dfxtp_1
XTAP_TAPCELL_ROW_20_222 VGND VPWR sky130_fd_sc_hd__tapvpwrvgnd_1
XFILLER_18_327 VGND VGND VPWR VPWR sky130_fd_sc_hd__decap_3
X_1330_ clkload4/A _1410_/D _1343_/DE VGND VGND VPWR VPWR _1330_/Q sky130_fd_sc_hd__edfxtp_1
X_1261_ _1459_/CLK _1453_/D _1263_/DE VGND VGND VPWR VPWR _1261_/Q sky130_fd_sc_hd__edfxtp_1
XTAP_TAPCELL_ROW_1_95 VGND VPWR sky130_fd_sc_hd__tapvpwrvgnd_1
XFILLER_17_371 VGND VGND VPWR VPWR sky130_fd_sc_hd__decap_3
Xinput7 data[2] VGND VGND VPWR VPWR input7/X sky130_fd_sc_hd__buf_2
X_1192_ _1192_/A _1412_/D VGND VGND VPWR VPWR _1192_/Y sky130_fd_sc_hd__nand2_1
X_0976_ _1049_/A VGND VGND VPWR VPWR _1082_/A sky130_fd_sc_hd__inv_8
XFILLER_27_102 VGND VGND VPWR VPWR sky130_fd_sc_hd__fill_2
X_1459_ _1459_/CLK _1459_/D VGND VGND VPWR VPWR _1459_/Q sky130_fd_sc_hd__dfxtp_1
XFILLER_23_341 VGND VGND VPWR VPWR sky130_fd_sc_hd__fill_1
XFILLER_35_69 VGND VGND VPWR VPWR sky130_fd_sc_hd__decap_12
XFILLER_4_3 VGND VGND VPWR VPWR sky130_fd_sc_hd__fill_1
XFILLER_18_102 VGND VGND VPWR VPWR sky130_fd_sc_hd__fill_2
XFILLER_33_116 VGND VGND VPWR VPWR sky130_fd_sc_hd__fill_2
X_0830_ _1045_/A _1369_/Q VGND VGND VPWR VPWR _0830_/Y sky130_fd_sc_hd__nand2_1
X_0761_ _0757_/Y _0758_/Y _0759_/Y _0760_/Y VGND VGND VPWR VPWR _0762_/D sky130_fd_sc_hd__o211a_1
X_0692_ _1083_/A _1446_/Q VGND VGND VPWR VPWR _0693_/D sky130_fd_sc_hd__nand2_1
X_1313_ clkload9/A _1441_/D _1326_/DE VGND VGND VPWR VPWR _1313_/Q sky130_fd_sc_hd__edfxtp_1
X_1244_ clkload5/A _1420_/D _1247_/DE VGND VGND VPWR VPWR _1244_/Q sky130_fd_sc_hd__edfxtp_1
XPHY_EDGE_ROW_22_Left_62 VGND VGND VPWR VPWR sky130_fd_sc_hd__decap_3
XFILLER_24_149 VGND VGND VPWR VPWR sky130_fd_sc_hd__fill_1
X_1175_ _1192_/A _1417_/D VGND VGND VPWR VPWR _1175_/Y sky130_fd_sc_hd__nand2_1
XFILLER_20_333 VGND VGND VPWR VPWR sky130_fd_sc_hd__decap_12
X_0959_ _1045_/A _1321_/Q VGND VGND VPWR VPWR _0961_/A sky130_fd_sc_hd__nand2_1
XFILLER_11_377 VGND VGND VPWR VPWR sky130_fd_sc_hd__fill_1
XFILLER_11_71 VGND VGND VPWR VPWR sky130_fd_sc_hd__decap_4
XFILLER_7_337 VGND VGND VPWR VPWR sky130_fd_sc_hd__fill_2
Xinput10 data[5] VGND VGND VPWR VPWR _1187_/B sky130_fd_sc_hd__buf_2
X_0813_ _0943_/X _1363_/Q VGND VGND VPWR VPWR _0815_/A sky130_fd_sc_hd__nand2_1
X_0744_ _1120_/A _1413_/Q VGND VGND VPWR VPWR _0745_/A sky130_fd_sc_hd__nand2_1
X_0675_ _0675_/A _0675_/B VGND VGND VPWR VPWR _0677_/B sky130_fd_sc_hd__nand2_1
X_1227_ clkload1/A _1419_/D _1231_/DE VGND VGND VPWR VPWR _1227_/Q sky130_fd_sc_hd__edfxtp_1
X_1158_ _1198_/A VGND VGND VPWR VPWR _1197_/A sky130_fd_sc_hd__inv_1
XFILLER_20_141 VGND VGND VPWR VPWR sky130_fd_sc_hd__decap_4
X_1089_ _1089_/A _1245_/Q VGND VGND VPWR VPWR _1091_/A sky130_fd_sc_hd__nand2_2
XFILLER_4_307 VGND VGND VPWR VPWR sky130_fd_sc_hd__fill_1
XTAP_TAPCELL_ROW_7_134 VGND VPWR sky130_fd_sc_hd__tapvpwrvgnd_1
XFILLER_11_141 VGND VGND VPWR VPWR sky130_fd_sc_hd__decap_12
XFILLER_7_145 VGND VGND VPWR VPWR sky130_fd_sc_hd__decap_6
X_1012_ _1046_/A _1288_/Q VGND VGND VPWR VPWR _1012_/Y sky130_fd_sc_hd__nand2_1
XTAP_TAPCELL_ROW_29_280 VGND VPWR sky130_fd_sc_hd__tapvpwrvgnd_1
X_0727_ _1093_/A _1400_/Q VGND VGND VPWR VPWR _0728_/B sky130_fd_sc_hd__nand2_1
XFILLER_8_94 VGND VGND VPWR VPWR sky130_fd_sc_hd__decap_6
X_0658_ _1079_/A _1431_/Q VGND VGND VPWR VPWR _0662_/A sky130_fd_sc_hd__nand2_1
XTAP_TAPCELL_ROW_4_115 VGND VPWR sky130_fd_sc_hd__tapvpwrvgnd_1
XFILLER_27_48 VGND VGND VPWR VPWR sky130_fd_sc_hd__decap_4
XFILLER_0_365 VGND VGND VPWR VPWR sky130_fd_sc_hd__decap_12
XTAP_TAPCELL_ROW_18_206 VGND VPWR sky130_fd_sc_hd__tapvpwrvgnd_1
XFILLER_16_277 VGND VGND VPWR VPWR sky130_fd_sc_hd__decap_12
XFILLER_31_225 VGND VGND VPWR VPWR sky130_fd_sc_hd__decap_4
XTAP_TAPCELL_ROW_26_261 VGND VPWR sky130_fd_sc_hd__tapvpwrvgnd_1
XFILLER_33_80 VGND VGND VPWR VPWR sky130_fd_sc_hd__fill_1
X_1492_ _1494_/CLK _1492_/D VGND VGND VPWR VPWR _1492_/Q sky130_fd_sc_hd__dfxtp_1
Xfanout29 _0754_/Y VGND VGND VPWR VPWR _0650_/B sky130_fd_sc_hd__clkdlybuf4s50_1
XTAP_TAPCELL_ROW_32_297 VGND VPWR sky130_fd_sc_hd__tapvpwrvgnd_1
XFILLER_13_225 VGND VGND VPWR VPWR sky130_fd_sc_hd__decap_8
X_0992_ _1053_/A _1265_/Q _0991_/X VGND VGND VPWR VPWR _0993_/D sky130_fd_sc_hd__a21oi_2
X_1475_ _1494_/CLK _1475_/D VGND VGND VPWR VPWR _1475_/Q sky130_fd_sc_hd__dfxtp_1
XFILLER_35_361 VGND VGND VPWR VPWR sky130_fd_sc_hd__decap_12
Xinput8 data[3] VGND VGND VPWR VPWR input8/X sky130_fd_sc_hd__buf_2
X_1260_ _1459_/CLK _1452_/D _1263_/DE VGND VGND VPWR VPWR _1260_/Q sky130_fd_sc_hd__edfxtp_1
X_1191_ _1191_/A input9/X VGND VGND VPWR VPWR _1191_/Y sky130_fd_sc_hd__nand2_1
XTAP_TAPCELL_ROW_1_96 VGND VPWR sky130_fd_sc_hd__tapvpwrvgnd_1
XFILLER_24_309 VGND VGND VPWR VPWR sky130_fd_sc_hd__fill_1
XFILLER_32_320 VGND VGND VPWR VPWR sky130_fd_sc_hd__decap_8
X_0975_ _1083_/A _0973_/Y _0974_/Y VGND VGND VPWR VPWR _0975_/Y sky130_fd_sc_hd__o21ai_1
X_1389_ clkload2/A _1421_/D _1389_/DE VGND VGND VPWR VPWR _1389_/Q sky130_fd_sc_hd__edfxtp_1
X_1458_ clkload7/A _1458_/D VGND VGND VPWR VPWR _1458_/Q sky130_fd_sc_hd__dfxtp_1
X_0760_ _1092_/A _1417_/Q VGND VGND VPWR VPWR _0760_/Y sky130_fd_sc_hd__nand2_1
X_0691_ _1440_/Q _1080_/A VGND VGND VPWR VPWR _0693_/C sky130_fd_sc_hd__nand2_1
X_1312_ clkload9/A _1440_/D _1326_/DE VGND VGND VPWR VPWR _1312_/Q sky130_fd_sc_hd__edfxtp_1
X_1243_ _1469_/CLK _1419_/D _0613_/A VGND VGND VPWR VPWR _1243_/Q sky130_fd_sc_hd__edfxtp_1
X_1174_ _1191_/A _1411_/D VGND VGND VPWR VPWR _1174_/Y sky130_fd_sc_hd__nand2_1
XFILLER_20_345 VGND VGND VPWR VPWR sky130_fd_sc_hd__fill_2
X_0958_ _0958_/A VGND VGND VPWR VPWR _0958_/Y sky130_fd_sc_hd__inv_1
X_0889_ _0889_/A _0889_/B VGND VGND VPWR VPWR _0890_/B sky130_fd_sc_hd__nand2_1
XFILLER_15_117 VGND VGND VPWR VPWR sky130_fd_sc_hd__decap_4
XFILLER_14_161 VGND VGND VPWR VPWR sky130_fd_sc_hd__fill_2
Xinput11 op[0] VGND VGND VPWR VPWR _1154_/B sky130_fd_sc_hd__buf_2
X_0812_ _1109_/A _1364_/Q _0932_/A _1362_/Q _0811_/Y VGND VGND VPWR VPWR _0833_/A
+ sky130_fd_sc_hd__a221oi_1
X_0743_ _0743_/A VGND VGND VPWR VPWR _0754_/A sky130_fd_sc_hd__inv_1
Xclkbuf_1_0__f_clk clkbuf_0_clk/X VGND VGND VPWR VPWR clkbuf_leaf_4_clk/A sky130_fd_sc_hd__clkbuf_16
X_0674_ _1093_/A _1432_/Q VGND VGND VPWR VPWR _0675_/B sky130_fd_sc_hd__nand2_1
X_1226_ clkload1/A _1418_/D _1231_/DE VGND VGND VPWR VPWR _1226_/Q sky130_fd_sc_hd__edfxtp_1
X_1157_ _1157_/A _1157_/B VGND VGND VPWR VPWR _1157_/Y sky130_fd_sc_hd__nor2_2
X_1088_ _1088_/A _1088_/B VGND VGND VPWR VPWR _1121_/A sky130_fd_sc_hd__nand2_2
XFILLER_20_197 VGND VGND VPWR VPWR sky130_fd_sc_hd__decap_3
XTAP_TAPCELL_ROW_7_135 VGND VPWR sky130_fd_sc_hd__tapvpwrvgnd_1
XFILLER_11_153 VGND VGND VPWR VPWR sky130_fd_sc_hd__decap_8
XFILLER_3_341 VGND VGND VPWR VPWR sky130_fd_sc_hd__fill_1
X_1011_ _1292_/Q _1070_/B VGND VGND VPWR VPWR _1011_/Y sky130_fd_sc_hd__nor2_1
X_0726_ _1045_/A _1401_/Q VGND VGND VPWR VPWR _0728_/A sky130_fd_sc_hd__nand2_1
XTAP_TAPCELL_ROW_12_170 VGND VPWR sky130_fd_sc_hd__tapvpwrvgnd_1
X_0657_ _0657_/A _1457_/Q VGND VGND VPWR VPWR _0685_/A sky130_fd_sc_hd__nand2_1
XTAP_TAPCELL_ROW_4_116 VGND VPWR sky130_fd_sc_hd__tapvpwrvgnd_1
XFILLER_25_223 VGND VGND VPWR VPWR sky130_fd_sc_hd__fill_1
X_1209_ clkload6/A _1449_/D _0619_/B VGND VGND VPWR VPWR _1209_/Q sky130_fd_sc_hd__edfxtp_1
XFILLER_0_333 VGND VGND VPWR VPWR sky130_fd_sc_hd__decap_3
XFILLER_0_377 VGND VGND VPWR VPWR sky130_fd_sc_hd__fill_1
XTAP_TAPCELL_ROW_18_207 VGND VPWR sky130_fd_sc_hd__tapvpwrvgnd_1
XFILLER_16_289 VGND VGND VPWR VPWR sky130_fd_sc_hd__decap_4
XFILLER_31_204 VGND VGND VPWR VPWR sky130_fd_sc_hd__fill_1
XFILLER_12_3 VGND VGND VPWR VPWR sky130_fd_sc_hd__fill_1
XFILLER_39_304 VGND VGND VPWR VPWR sky130_fd_sc_hd__decap_4
X_1491_ _1494_/CLK _1491_/D VGND VGND VPWR VPWR _1491_/Q sky130_fd_sc_hd__dfxtp_1
XFILLER_22_204 VGND VGND VPWR VPWR sky130_fd_sc_hd__decap_8
XFILLER_30_270 VGND VGND VPWR VPWR sky130_fd_sc_hd__fill_1
XTAP_TAPCELL_ROW_32_298 VGND VPWR sky130_fd_sc_hd__tapvpwrvgnd_1
X_0709_ _0709_/A VGND VGND VPWR VPWR _0931_/A sky130_fd_sc_hd__inv_1
XFILLER_38_48 VGND VGND VPWR VPWR sky130_fd_sc_hd__decap_4
XFILLER_21_281 VGND VGND VPWR VPWR sky130_fd_sc_hd__decap_6
XFILLER_28_81 VGND VGND VPWR VPWR sky130_fd_sc_hd__decap_3
X_0991_ _1120_/X _1269_/Q _1063_/A _1275_/Q VGND VGND VPWR VPWR _0991_/X sky130_fd_sc_hd__a22o_1
X_1474_ _1494_/CLK _1474_/D VGND VGND VPWR VPWR _1474_/Q sky130_fd_sc_hd__dfxtp_1
XFILLER_35_373 VGND VGND VPWR VPWR sky130_fd_sc_hd__decap_4
XFILLER_26_362 VGND VGND VPWR VPWR sky130_fd_sc_hd__fill_2
XFILLER_5_211 VGND VGND VPWR VPWR sky130_fd_sc_hd__fill_1
Xinput9 data[4] VGND VGND VPWR VPWR input9/X sky130_fd_sc_hd__buf_2
X_1190_ _1187_/Y _1188_/Y _1193_/B1 VGND VGND VPWR VPWR _1477_/D sky130_fd_sc_hd__a21oi_1
XTAP_TAPCELL_ROW_1_97 VGND VPWR sky130_fd_sc_hd__tapvpwrvgnd_1
X_0974_ _1104_/A _1266_/Q VGND VGND VPWR VPWR _0974_/Y sky130_fd_sc_hd__nand2_1
X_1457_ _1469_/CLK _1457_/D VGND VGND VPWR VPWR _1457_/Q sky130_fd_sc_hd__dfxtp_1
XFILLER_35_49 VGND VGND VPWR VPWR sky130_fd_sc_hd__decap_6
X_1388_ clkload2/A _1420_/D _1389_/DE VGND VGND VPWR VPWR _1388_/Q sky130_fd_sc_hd__edfxtp_1
XFILLER_14_365 VGND VGND VPWR VPWR sky130_fd_sc_hd__decap_12
XFILLER_18_148 VGND VGND VPWR VPWR sky130_fd_sc_hd__fill_1
X_0690_ _1082_/A _1441_/Q VGND VGND VPWR VPWR _0693_/B sky130_fd_sc_hd__nand2_1
X_1311_ _1466_/CLK _1455_/D _1311_/DE VGND VGND VPWR VPWR _1311_/Q sky130_fd_sc_hd__edfxtp_1
X_1242_ _1459_/CLK _1418_/D _0613_/A VGND VGND VPWR VPWR _1242_/Q sky130_fd_sc_hd__edfxtp_1
X_1173_ _1171_/Y _1172_/Y _0642_/A VGND VGND VPWR VPWR _1486_/D sky130_fd_sc_hd__a21oi_1
XPHY_EDGE_ROW_10_Right_10 VGND VGND VPWR VPWR sky130_fd_sc_hd__decap_3
XFILLER_24_118 VGND VGND VPWR VPWR sky130_fd_sc_hd__decap_12
X_0957_ _1100_/A _1322_/Q VGND VGND VPWR VPWR _0958_/A sky130_fd_sc_hd__nand2_1
X_0888_ _1049_/A _1200_/Q VGND VGND VPWR VPWR _0889_/B sky130_fd_sc_hd__nand2_1
XFILLER_23_184 VGND VGND VPWR VPWR sky130_fd_sc_hd__decap_12
XFILLER_36_70 VGND VGND VPWR VPWR sky130_fd_sc_hd__decap_12
Xinput12 op[1] VGND VGND VPWR VPWR _0798_/A sky130_fd_sc_hd__buf_2
X_0811_ _0923_/A _0808_/Y _0810_/Y VGND VGND VPWR VPWR _0811_/Y sky130_fd_sc_hd__o21ai_1
X_0742_ _1109_/A _1412_/Q _0932_/A _1410_/Q _0741_/Y VGND VGND VPWR VPWR _0762_/A
+ sky130_fd_sc_hd__a221oi_1
X_0673_ _1092_/A _1433_/Q VGND VGND VPWR VPWR _0675_/A sky130_fd_sc_hd__nand2_1
X_1225_ clkload6/A _1417_/D _1229_/DE VGND VGND VPWR VPWR _1225_/Q sky130_fd_sc_hd__edfxtp_1
X_1156_ _0968_/A _1155_/Y _0967_/A VGND VGND VPWR VPWR _1156_/Y sky130_fd_sc_hd__a21oi_2
X_1087_ input8/X _1131_/B VGND VGND VPWR VPWR _1087_/Y sky130_fd_sc_hd__nor2_1
XTAP_TAPCELL_ROW_7_136 VGND VPWR sky130_fd_sc_hd__tapvpwrvgnd_1
XFILLER_11_165 VGND VGND VPWR VPWR sky130_fd_sc_hd__decap_3
XFILLER_22_61 VGND VGND VPWR VPWR sky130_fd_sc_hd__fill_1
X_1010_ _1090_/B _1293_/Q VGND VGND VPWR VPWR _1010_/Y sky130_fd_sc_hd__nor2_1
XFILLER_8_85 VGND VGND VPWR VPWR sky130_fd_sc_hd__decap_3
Xclkbuf_leaf_6_clk clkload0/A VGND VGND VPWR VPWR clkload9/A sky130_fd_sc_hd__clkbuf_16
X_0725_ _1109_/A _1396_/Q _1076_/X _1399_/Q _0724_/Y VGND VGND VPWR VPWR _0738_/B
+ sky130_fd_sc_hd__a221oi_2
X_0656_ _1120_/A _1429_/Q VGND VGND VPWR VPWR _0657_/A sky130_fd_sc_hd__nand2_1
X_1208_ clkload6/A _1448_/D _0619_/B VGND VGND VPWR VPWR _1208_/Q sky130_fd_sc_hd__edfxtp_1
XTAP_TAPCELL_ROW_4_117 VGND VPWR sky130_fd_sc_hd__tapvpwrvgnd_1
XFILLER_25_268 VGND VGND VPWR VPWR sky130_fd_sc_hd__fill_1
XFILLER_25_279 VGND VGND VPWR VPWR sky130_fd_sc_hd__fill_1
X_1139_ _1139_/A _1139_/B VGND VGND VPWR VPWR _1140_/A sky130_fd_sc_hd__nand2_1
XFILLER_4_139 VGND VGND VPWR VPWR sky130_fd_sc_hd__fill_1
XTAP_TAPCELL_ROW_18_208 VGND VPWR sky130_fd_sc_hd__tapvpwrvgnd_1
X_1490_ _1494_/CLK _1490_/D VGND VGND VPWR VPWR _1490_/Q sky130_fd_sc_hd__dfxtp_1
XFILLER_22_238 VGND VGND VPWR VPWR sky130_fd_sc_hd__decap_12
XPHY_EDGE_ROW_8_Right_8 VGND VGND VPWR VPWR sky130_fd_sc_hd__decap_3
XTAP_TAPCELL_ROW_32_299 VGND VPWR sky130_fd_sc_hd__tapvpwrvgnd_1
X_0708_ _0708_/A VGND VGND VPWR VPWR _0708_/Y sky130_fd_sc_hd__inv_2
X_0639_ _0639_/A _0639_/B VGND VGND VPWR VPWR _1463_/D sky130_fd_sc_hd__nor2_2
XPHY_EDGE_ROW_39_Right_39 VGND VGND VPWR VPWR sky130_fd_sc_hd__decap_3
XFILLER_0_197 VGND VGND VPWR VPWR sky130_fd_sc_hd__fill_1
X_0990_ _0990_/A _0990_/B VGND VGND VPWR VPWR _0993_/C sky130_fd_sc_hd__nor2_1
X_1473_ _1494_/CLK _1473_/D VGND VGND VPWR VPWR _1473_/Q sky130_fd_sc_hd__dfxtp_1
XFILLER_39_113 VGND VGND VPWR VPWR sky130_fd_sc_hd__fill_2
XPHY_EDGE_ROW_39_Left_79 VGND VGND VPWR VPWR sky130_fd_sc_hd__decap_3
XFILLER_18_319 VGND VGND VPWR VPWR sky130_fd_sc_hd__decap_8
XTAP_TAPCELL_ROW_1_98 VGND VPWR sky130_fd_sc_hd__tapvpwrvgnd_1
XFILLER_5_289 VGND VGND VPWR VPWR sky130_fd_sc_hd__fill_1
XFILLER_5_223 VGND VGND VPWR VPWR sky130_fd_sc_hd__fill_1
X_0973_ _1271_/Q VGND VGND VPWR VPWR _0973_/Y sky130_fd_sc_hd__inv_1
X_1387_ clkload2/A _1419_/D _1389_/DE VGND VGND VPWR VPWR _1387_/Q sky130_fd_sc_hd__edfxtp_1
X_1456_ _1456_/CLK _1456_/D VGND VGND VPWR VPWR _1456_/Q sky130_fd_sc_hd__dfxtp_1
XFILLER_23_311 VGND VGND VPWR VPWR sky130_fd_sc_hd__decap_8
XFILLER_23_377 VGND VGND VPWR VPWR sky130_fd_sc_hd__fill_1
XFILLER_14_333 VGND VGND VPWR VPWR sky130_fd_sc_hd__decap_4
XFILLER_14_377 VGND VGND VPWR VPWR sky130_fd_sc_hd__fill_1
X_1310_ _1466_/CLK _1454_/D _1311_/DE VGND VGND VPWR VPWR _1310_/Q sky130_fd_sc_hd__edfxtp_1
X_1241_ clkload5/A _1449_/D _1247_/DE VGND VGND VPWR VPWR _1241_/Q sky130_fd_sc_hd__edfxtp_1
X_1172_ _1192_/A _1422_/D VGND VGND VPWR VPWR _1172_/Y sky130_fd_sc_hd__nand2_1
XFILLER_20_369 VGND VGND VPWR VPWR sky130_fd_sc_hd__fill_1
X_0956_ _1104_/A _1314_/Q _0955_/X VGND VGND VPWR VPWR _0963_/C sky130_fd_sc_hd__a21oi_1
X_0887_ _1093_/A VGND VGND VPWR VPWR _1092_/A sky130_fd_sc_hd__inv_6
X_1439_ _1469_/CLK _1455_/D _1439_/DE VGND VGND VPWR VPWR _1439_/Q sky130_fd_sc_hd__edfxtp_1
XFILLER_23_130 VGND VGND VPWR VPWR sky130_fd_sc_hd__fill_1
XFILLER_11_369 VGND VGND VPWR VPWR sky130_fd_sc_hd__decap_8
XFILLER_23_196 VGND VGND VPWR VPWR sky130_fd_sc_hd__decap_12
XFILLER_2_3 VGND VGND VPWR VPWR sky130_fd_sc_hd__fill_1
XFILLER_36_82 VGND VGND VPWR VPWR sky130_fd_sc_hd__fill_2
XFILLER_14_141 VGND VGND VPWR VPWR sky130_fd_sc_hd__decap_12
Xinput13 rst VGND VGND VPWR VPWR input13/X sky130_fd_sc_hd__buf_2
X_0810_ _0923_/A _1374_/Q VGND VGND VPWR VPWR _0810_/Y sky130_fd_sc_hd__nand2_1
XPHY_EDGE_ROW_26_Left_66 VGND VGND VPWR VPWR sky130_fd_sc_hd__decap_3
X_0741_ _0923_/A _0739_/Y _0740_/Y VGND VGND VPWR VPWR _0741_/Y sky130_fd_sc_hd__o21ai_0
X_0672_ _0672_/A _0672_/B VGND VGND VPWR VPWR _0677_/A sky130_fd_sc_hd__nand2_1
XFILLER_35_3 VGND VGND VPWR VPWR sky130_fd_sc_hd__decap_6
X_1224_ clkload1/A _1416_/D _1231_/DE VGND VGND VPWR VPWR _1224_/Q sky130_fd_sc_hd__edfxtp_1
X_1155_ _1155_/A _1155_/B VGND VGND VPWR VPWR _1155_/Y sky130_fd_sc_hd__nand2_1
X_1086_ _1120_/X _1237_/Q _0614_/Y VGND VGND VPWR VPWR _1088_/B sky130_fd_sc_hd__a21oi_4
XFILLER_20_133 VGND VGND VPWR VPWR sky130_fd_sc_hd__decap_6
X_0939_ _0939_/A _0939_/B VGND VGND VPWR VPWR _0940_/A sky130_fd_sc_hd__nor2_1
XTAP_TAPCELL_ROW_7_137 VGND VPWR sky130_fd_sc_hd__tapvpwrvgnd_1
XFILLER_28_200 VGND VGND VPWR VPWR sky130_fd_sc_hd__decap_4
XFILLER_28_277 VGND VGND VPWR VPWR sky130_fd_sc_hd__decap_4
XFILLER_11_199 VGND VGND VPWR VPWR sky130_fd_sc_hd__decap_12
XFILLER_7_137 VGND VGND VPWR VPWR sky130_fd_sc_hd__fill_2
XFILLER_19_266 VGND VGND VPWR VPWR sky130_fd_sc_hd__fill_1
XFILLER_19_277 VGND VGND VPWR VPWR sky130_fd_sc_hd__decap_3
X_0724_ _0724_/A _0724_/B VGND VGND VPWR VPWR _0724_/Y sky130_fd_sc_hd__nand2_1
X_0655_ _0655_/A VGND VGND VPWR VPWR _1458_/D sky130_fd_sc_hd__buf_2
X_1207_ clkload6/A _1415_/D _0619_/B VGND VGND VPWR VPWR _1207_/Q sky130_fd_sc_hd__edfxtp_1
XTAP_TAPCELL_ROW_4_118 VGND VPWR sky130_fd_sc_hd__tapvpwrvgnd_1
XFILLER_25_225 VGND VGND VPWR VPWR sky130_fd_sc_hd__decap_12
X_1138_ _1138_/A _1138_/B VGND VGND VPWR VPWR _1139_/A sky130_fd_sc_hd__nand2_1
X_1069_ _1261_/Q _1090_/B VGND VGND VPWR VPWR _1069_/Y sky130_fd_sc_hd__nor2_1
XTAP_TAPCELL_ROW_18_209 VGND VPWR sky130_fd_sc_hd__tapvpwrvgnd_1
X_0707_ _1107_/B _1454_/Q VGND VGND VPWR VPWR _0708_/A sky130_fd_sc_hd__nand2_1
X_0638_ _0638_/A _0638_/B VGND VGND VPWR VPWR _0639_/B sky130_fd_sc_hd__nor2_1
XPHY_EDGE_ROW_13_Left_53 VGND VGND VPWR VPWR sky130_fd_sc_hd__decap_3
XFILLER_13_217 VGND VGND VPWR VPWR sky130_fd_sc_hd__fill_1
X_1472_ _1494_/CLK _1472_/D VGND VGND VPWR VPWR _1472_/Q sky130_fd_sc_hd__dfxtp_1
XFILLER_18_309 VGND VGND VPWR VPWR sky130_fd_sc_hd__fill_1
XFILLER_26_320 VGND VGND VPWR VPWR sky130_fd_sc_hd__decap_4
XFILLER_5_268 VGND VGND VPWR VPWR sky130_fd_sc_hd__fill_1
XFILLER_32_301 VGND VGND VPWR VPWR sky130_fd_sc_hd__decap_6
X_0972_ _0972_/A _0972_/B VGND VGND VPWR VPWR _1078_/A sky130_fd_sc_hd__nor2_1
XTAP_TAPCELL_ROW_34_307 VGND VPWR sky130_fd_sc_hd__tapvpwrvgnd_1
X_1386_ clkload2/A _1418_/D _1389_/DE VGND VGND VPWR VPWR _1386_/Q sky130_fd_sc_hd__edfxtp_1
X_1455_ _1469_/CLK _1455_/D _1455_/DE VGND VGND VPWR VPWR _1455_/Q sky130_fd_sc_hd__edfxtp_1
XFILLER_18_139 VGND VGND VPWR VPWR sky130_fd_sc_hd__fill_1
XFILLER_37_7 VGND VGND VPWR VPWR sky130_fd_sc_hd__fill_1
X_1240_ _1456_/CLK _1448_/D _1247_/DE VGND VGND VPWR VPWR _1240_/Q sky130_fd_sc_hd__edfxtp_1
X_1171_ _1191_/A _1416_/D VGND VGND VPWR VPWR _1171_/Y sky130_fd_sc_hd__nand2_1
XFILLER_2_88 VGND VGND VPWR VPWR sky130_fd_sc_hd__fill_1
X_0955_ _1103_/A _1316_/Q _0943_/X _1315_/Q VGND VGND VPWR VPWR _0955_/X sky130_fd_sc_hd__a22o_1
X_0886_ _1099_/A _1203_/Q VGND VGND VPWR VPWR _0889_/A sky130_fd_sc_hd__nand2_1
X_1369_ clkload3/A _1417_/D _0634_/B VGND VGND VPWR VPWR _1369_/Q sky130_fd_sc_hd__edfxtp_1
X_1438_ _1469_/CLK _1454_/D _1439_/DE VGND VGND VPWR VPWR _1438_/Q sky130_fd_sc_hd__edfxtp_1
XFILLER_11_337 VGND VGND VPWR VPWR sky130_fd_sc_hd__fill_1
XFILLER_11_75 VGND VGND VPWR VPWR sky130_fd_sc_hd__fill_1
XPHY_EDGE_ROW_1_Left_41 VGND VGND VPWR VPWR sky130_fd_sc_hd__decap_3
XFILLER_14_153 VGND VGND VPWR VPWR sky130_fd_sc_hd__decap_8
XFILLER_14_175 VGND VGND VPWR VPWR sky130_fd_sc_hd__fill_1
X_0740_ _0923_/A _1422_/Q VGND VGND VPWR VPWR _0740_/Y sky130_fd_sc_hd__nand2_1
X_0671_ _0998_/A _1436_/Q VGND VGND VPWR VPWR _0672_/B sky130_fd_sc_hd__nand2_1
XFILLER_6_363 VGND VGND VPWR VPWR sky130_fd_sc_hd__fill_1
X_1223_ clkload6/A _1415_/D _1229_/DE VGND VGND VPWR VPWR _1223_/Q sky130_fd_sc_hd__edfxtp_1
X_1154_ _1154_/A _1154_/B VGND VGND VPWR VPWR _1198_/A sky130_fd_sc_hd__nand2_1
X_1085_ _1085_/A _1085_/B VGND VGND VPWR VPWR _1088_/A sky130_fd_sc_hd__nor2_1
XFILLER_20_145 VGND VGND VPWR VPWR sky130_fd_sc_hd__fill_1
X_0938_ _0938_/A _0938_/B _0938_/C VGND VGND VPWR VPWR _0939_/B sky130_fd_sc_hd__nand3_1
X_0869_ _1201_/Q VGND VGND VPWR VPWR _0870_/B sky130_fd_sc_hd__inv_2
XFILLER_7_105 VGND VGND VPWR VPWR sky130_fd_sc_hd__fill_1
XFILLER_19_223 VGND VGND VPWR VPWR sky130_fd_sc_hd__fill_1
X_0723_ _0932_/A _1394_/Q VGND VGND VPWR VPWR _0724_/B sky130_fd_sc_hd__nand2_1
XFILLER_8_54 VGND VGND VPWR VPWR sky130_fd_sc_hd__fill_1
X_0654_ _0776_/A _0787_/B VGND VGND VPWR VPWR _0654_/Y sky130_fd_sc_hd__nor2_1
XFILLER_6_193 VGND VGND VPWR VPWR sky130_fd_sc_hd__decap_3
X_1206_ clkload6/A _1414_/D _1212_/DE VGND VGND VPWR VPWR _1206_/Q sky130_fd_sc_hd__edfxtp_1
X_1137_ _1137_/A _1137_/B VGND VGND VPWR VPWR _1138_/A sky130_fd_sc_hd__nand2_1
X_1068_ _1068_/A _1068_/B VGND VGND VPWR VPWR _1073_/B sky130_fd_sc_hd__nand2_1
XFILLER_0_303 VGND VGND VPWR VPWR sky130_fd_sc_hd__fill_1
XFILLER_3_163 VGND VGND VPWR VPWR sky130_fd_sc_hd__fill_2
XFILLER_15_281 VGND VGND VPWR VPWR sky130_fd_sc_hd__decap_12
X_0706_ _0706_/A _0706_/B VGND VGND VPWR VPWR _0714_/A sky130_fd_sc_hd__nor2_1
X_0637_ _0637_/A VGND VGND VPWR VPWR _1460_/D sky130_fd_sc_hd__buf_2
XTAP_TAPCELL_ROW_31_290 VGND VPWR sky130_fd_sc_hd__tapvpwrvgnd_1
XFILLER_0_177 VGND VGND VPWR VPWR sky130_fd_sc_hd__fill_1
XFILLER_28_40 VGND VGND VPWR VPWR sky130_fd_sc_hd__decap_12
XFILLER_12_262 VGND VGND VPWR VPWR sky130_fd_sc_hd__fill_2
XPHY_EDGE_ROW_30_Left_70 VGND VGND VPWR VPWR sky130_fd_sc_hd__decap_3
XFILLER_5_55 VGND VGND VPWR VPWR sky130_fd_sc_hd__fill_1
XFILLER_5_11 VGND VGND VPWR VPWR sky130_fd_sc_hd__fill_1
XFILLER_10_3 VGND VGND VPWR VPWR sky130_fd_sc_hd__decap_8
XFILLER_39_126 VGND VGND VPWR VPWR sky130_fd_sc_hd__fill_1
X_1471_ clkload6/A _1471_/D VGND VGND VPWR VPWR _1471_/Q sky130_fd_sc_hd__dfxtp_1
XTAP_TAPCELL_ROW_37_327 VGND VPWR sky130_fd_sc_hd__tapvpwrvgnd_1
XTAP_TAPCELL_ROW_20_216 VGND VPWR sky130_fd_sc_hd__tapvpwrvgnd_1
XFILLER_26_376 VGND VGND VPWR VPWR sky130_fd_sc_hd__fill_2
XFILLER_14_97 VGND VGND VPWR VPWR sky130_fd_sc_hd__fill_1
XFILLER_5_225 VGND VGND VPWR VPWR sky130_fd_sc_hd__decap_12
XFILLER_30_85 VGND VGND VPWR VPWR sky130_fd_sc_hd__decap_12
XFILLER_17_332 VGND VGND VPWR VPWR sky130_fd_sc_hd__fill_1
XFILLER_17_343 VGND VGND VPWR VPWR sky130_fd_sc_hd__fill_2
XFILLER_36_118 VGND VGND VPWR VPWR sky130_fd_sc_hd__fill_2
XTAP_TAPCELL_ROW_34_308 VGND VPWR sky130_fd_sc_hd__tapvpwrvgnd_1
X_0971_ _1137_/B _1130_/A _0970_/Y VGND VGND VPWR VPWR _0972_/B sky130_fd_sc_hd__o21ai_1
XFILLER_4_291 VGND VGND VPWR VPWR sky130_fd_sc_hd__decap_4
X_1454_ _1469_/CLK _1454_/D _1455_/DE VGND VGND VPWR VPWR _1454_/Q sky130_fd_sc_hd__edfxtp_1
X_1385_ clkload2/A _1417_/D _1389_/DE VGND VGND VPWR VPWR _1385_/Q sky130_fd_sc_hd__edfxtp_1
XFILLER_23_335 VGND VGND VPWR VPWR sky130_fd_sc_hd__fill_1
XFILLER_25_41 VGND VGND VPWR VPWR sky130_fd_sc_hd__decap_8
X_1170_ _1168_/Y _1169_/Y _0642_/A VGND VGND VPWR VPWR _1487_/D sky130_fd_sc_hd__a21oi_1
XFILLER_17_195 VGND VGND VPWR VPWR sky130_fd_sc_hd__fill_2
XFILLER_32_187 VGND VGND VPWR VPWR sky130_fd_sc_hd__fill_1
X_0954_ _1060_/B _0998_/B VGND VGND VPWR VPWR _0954_/Y sky130_fd_sc_hd__nor2_1
X_0885_ _0885_/A _0885_/B VGND VGND VPWR VPWR _0890_/A sky130_fd_sc_hd__nand2_1
X_1437_ _1456_/CLK _1453_/D _1437_/DE VGND VGND VPWR VPWR _1437_/Q sky130_fd_sc_hd__edfxtp_1
X_1299_ _1466_/CLK _1443_/D _0625_/B VGND VGND VPWR VPWR _1299_/Q sky130_fd_sc_hd__edfxtp_1
X_1368_ clkload3/A _1416_/D _0634_/B VGND VGND VPWR VPWR _1368_/Q sky130_fd_sc_hd__edfxtp_1
XFILLER_11_327 VGND VGND VPWR VPWR sky130_fd_sc_hd__fill_2
XFILLER_7_309 VGND VGND VPWR VPWR sky130_fd_sc_hd__fill_1
X_0670_ _1089_/A _1437_/Q VGND VGND VPWR VPWR _0672_/A sky130_fd_sc_hd__nand2_1
X_1222_ clkload6/A _1414_/D _1229_/DE VGND VGND VPWR VPWR _1222_/Q sky130_fd_sc_hd__edfxtp_1
X_1153_ input4/X VGND VGND VPWR VPWR _1167_/B sky130_fd_sc_hd__inv_1
X_1084_ _1084_/A _1084_/B VGND VGND VPWR VPWR _1085_/B sky130_fd_sc_hd__nand2_1
Xclkbuf_leaf_9_clk clkload0/A VGND VGND VPWR VPWR _1459_/CLK sky130_fd_sc_hd__clkbuf_16
X_0937_ _0937_/A _0937_/B VGND VGND VPWR VPWR _0938_/C sky130_fd_sc_hd__nor2_1
X_0868_ _0868_/A _0868_/B VGND VGND VPWR VPWR _0875_/A sky130_fd_sc_hd__nor2_1
X_0799_ _0799_/A _0799_/B VGND VGND VPWR VPWR _0804_/A sky130_fd_sc_hd__nand2_1
XFILLER_36_290 VGND VGND VPWR VPWR sky130_fd_sc_hd__fill_2
XFILLER_11_113 VGND VGND VPWR VPWR sky130_fd_sc_hd__decap_4
XFILLER_3_301 VGND VGND VPWR VPWR sky130_fd_sc_hd__fill_2
X_0722_ _1099_/A _1395_/Q VGND VGND VPWR VPWR _0724_/A sky130_fd_sc_hd__nand2_1
X_0653_ hold119/X _1423_/DE _0639_/A VGND VGND VPWR VPWR _0655_/A sky130_fd_sc_hd__o21ba_2
X_1205_ clkload5/A _1413_/D _1212_/DE VGND VGND VPWR VPWR _1205_/Q sky130_fd_sc_hd__edfxtp_1
X_1136_ _1136_/A _1136_/B VGND VGND VPWR VPWR _1137_/A sky130_fd_sc_hd__nand2_1
X_1067_ _1263_/Q _1262_/Q VGND VGND VPWR VPWR _1068_/B sky130_fd_sc_hd__nand2_1
XFILLER_0_337 VGND VGND VPWR VPWR sky130_fd_sc_hd__decap_12
XFILLER_17_64 VGND VGND VPWR VPWR sky130_fd_sc_hd__decap_3
XTAP_TAPCELL_ROW_26_255 VGND VPWR sky130_fd_sc_hd__tapvpwrvgnd_1
XFILLER_33_74 VGND VGND VPWR VPWR sky130_fd_sc_hd__decap_6
XTAP_TAPCELL_ROW_17_200 VGND VPWR sky130_fd_sc_hd__tapvpwrvgnd_1
XFILLER_15_293 VGND VGND VPWR VPWR sky130_fd_sc_hd__fill_1
X_0705_ _0705_/A _0705_/B VGND VGND VPWR VPWR _0706_/B sky130_fd_sc_hd__nand2_1
X_0636_ hold124/X _1391_/DE _0639_/A VGND VGND VPWR VPWR _0637_/A sky130_fd_sc_hd__o21ba_2
XFILLER_38_363 VGND VGND VPWR VPWR sky130_fd_sc_hd__fill_1
X_1119_ _1119_/A _1119_/B VGND VGND VPWR VPWR _1124_/A sky130_fd_sc_hd__nand2_1
XTAP_TAPCELL_ROW_23_236 VGND VPWR sky130_fd_sc_hd__tapvpwrvgnd_1
XFILLER_21_252 VGND VGND VPWR VPWR sky130_fd_sc_hd__decap_4
XTAP_TAPCELL_ROW_31_291 VGND VPWR sky130_fd_sc_hd__tapvpwrvgnd_1
XPHY_EDGE_ROW_17_Right_17 VGND VGND VPWR VPWR sky130_fd_sc_hd__decap_3
XPHY_EDGE_ROW_26_Right_26 VGND VGND VPWR VPWR sky130_fd_sc_hd__decap_3
XFILLER_28_52 VGND VGND VPWR VPWR sky130_fd_sc_hd__decap_3
XFILLER_28_85 VGND VGND VPWR VPWR sky130_fd_sc_hd__decap_12
XFILLER_12_230 VGND VGND VPWR VPWR sky130_fd_sc_hd__fill_2
XPHY_EDGE_ROW_35_Right_35 VGND VGND VPWR VPWR sky130_fd_sc_hd__decap_3
XFILLER_8_234 VGND VGND VPWR VPWR sky130_fd_sc_hd__decap_12
X_1470_ clkload5/A _1470_/D VGND VGND VPWR VPWR _1470_/Q sky130_fd_sc_hd__dfxtp_1
XFILLER_5_78 VGND VGND VPWR VPWR sky130_fd_sc_hd__decap_12
XFILLER_35_377 VGND VGND VPWR VPWR sky130_fd_sc_hd__fill_1
XTAP_TAPCELL_ROW_37_328 VGND VPWR sky130_fd_sc_hd__tapvpwrvgnd_1
XTAP_TAPCELL_ROW_20_217 VGND VPWR sky130_fd_sc_hd__tapvpwrvgnd_1
X_0619_ _0619_/A _0619_/B VGND VGND VPWR VPWR _0620_/B sky130_fd_sc_hd__nor2_1
XFILLER_38_193 VGND VGND VPWR VPWR sky130_fd_sc_hd__decap_3
XFILLER_30_97 VGND VGND VPWR VPWR sky130_fd_sc_hd__decap_4
XFILLER_5_237 VGND VGND VPWR VPWR sky130_fd_sc_hd__fill_1
XFILLER_17_322 VGND VGND VPWR VPWR sky130_fd_sc_hd__decap_3
XTAP_TAPCELL_ROW_34_309 VGND VPWR sky130_fd_sc_hd__tapvpwrvgnd_1
X_0970_ _1150_/A _0967_/A _1149_/A VGND VGND VPWR VPWR _0970_/Y sky130_fd_sc_hd__o21ai_0
X_1453_ _1456_/CLK _1453_/D _1453_/DE VGND VGND VPWR VPWR _1453_/Q sky130_fd_sc_hd__edfxtp_1
X_1384_ clkload2/A _1416_/D _1389_/DE VGND VGND VPWR VPWR _1384_/Q sky130_fd_sc_hd__edfxtp_1
XFILLER_23_369 VGND VGND VPWR VPWR sky130_fd_sc_hd__decap_8
XFILLER_14_358 VGND VGND VPWR VPWR sky130_fd_sc_hd__decap_6
XFILLER_25_86 VGND VGND VPWR VPWR sky130_fd_sc_hd__fill_2
X_0953_ _1083_/A _1318_/Q _1053_/A _1313_/Q _0952_/Y VGND VGND VPWR VPWR _0963_/B
+ sky130_fd_sc_hd__a221oi_1
X_0884_ _1093_/A _1208_/Q VGND VGND VPWR VPWR _0885_/B sky130_fd_sc_hd__nand2_1
XFILLER_9_373 VGND VGND VPWR VPWR sky130_fd_sc_hd__decap_4
X_1367_ _1494_/CLK _1415_/D _1375_/DE VGND VGND VPWR VPWR _1367_/Q sky130_fd_sc_hd__edfxtp_1
X_1436_ _1456_/CLK _1452_/D _1437_/DE VGND VGND VPWR VPWR _1436_/Q sky130_fd_sc_hd__edfxtp_1
X_1298_ _1466_/CLK _1442_/D _1311_/DE VGND VGND VPWR VPWR _1298_/Q sky130_fd_sc_hd__edfxtp_1
XFILLER_23_166 VGND VGND VPWR VPWR sky130_fd_sc_hd__fill_2
XFILLER_23_177 VGND VGND VPWR VPWR sky130_fd_sc_hd__fill_1
XFILLER_36_85 VGND VGND VPWR VPWR sky130_fd_sc_hd__decap_3
XFILLER_6_365 VGND VGND VPWR VPWR sky130_fd_sc_hd__decap_12
XFILLER_6_343 VGND VGND VPWR VPWR sky130_fd_sc_hd__decap_12
X_1221_ clkload6/A _1413_/D _1229_/DE VGND VGND VPWR VPWR _1221_/Q sky130_fd_sc_hd__edfxtp_1
X_1152_ _1152_/A VGND VGND VPWR VPWR _1152_/X sky130_fd_sc_hd__buf_2
X_1083_ _1083_/A _1238_/Q VGND VGND VPWR VPWR _1084_/B sky130_fd_sc_hd__nand2_1
XFILLER_20_158 VGND VGND VPWR VPWR sky130_fd_sc_hd__decap_8
X_0936_ _0936_/A _0936_/B VGND VGND VPWR VPWR _0937_/B sky130_fd_sc_hd__nand2_1
X_0867_ _0867_/A _0867_/B VGND VGND VPWR VPWR _0868_/B sky130_fd_sc_hd__nand2_1
X_0798_ _0798_/A VGND VGND VPWR VPWR _1154_/A sky130_fd_sc_hd__inv_1
X_1419_ clkload1/A _1419_/D _1421_/DE VGND VGND VPWR VPWR _1419_/Q sky130_fd_sc_hd__edfxtp_1
XFILLER_22_65 VGND VGND VPWR VPWR sky130_fd_sc_hd__decap_4
XFILLER_22_76 VGND VGND VPWR VPWR sky130_fd_sc_hd__decap_8
XFILLER_0_3 VGND VGND VPWR VPWR sky130_fd_sc_hd__decap_12
XFILLER_3_335 VGND VGND VPWR VPWR sky130_fd_sc_hd__fill_1
XFILLER_19_225 VGND VGND VPWR VPWR sky130_fd_sc_hd__decap_12
XTAP_TAPCELL_ROW_29_275 VGND VPWR sky130_fd_sc_hd__tapvpwrvgnd_1
X_0721_ _1042_/A _0776_/B VGND VGND VPWR VPWR _0721_/Y sky130_fd_sc_hd__nor2_2
X_0652_ _0754_/A _1042_/B VGND VGND VPWR VPWR _0652_/Y sky130_fd_sc_hd__nor2_1
XTAP_TAPCELL_ROW_12_164 VGND VPWR sky130_fd_sc_hd__tapvpwrvgnd_1
X_1204_ clkload6/A _1412_/D _0619_/B VGND VGND VPWR VPWR _1204_/Q sky130_fd_sc_hd__edfxtp_1
X_1135_ _1135_/A _1135_/B VGND VGND VPWR VPWR _1136_/A sky130_fd_sc_hd__nand2_1
X_1066_ _1255_/Q _1254_/Q VGND VGND VPWR VPWR _1068_/A sky130_fd_sc_hd__nand2_1
X_0919_ _0919_/A _0919_/B VGND VGND VPWR VPWR _0921_/B sky130_fd_sc_hd__nand2_1
XFILLER_0_349 VGND VGND VPWR VPWR sky130_fd_sc_hd__decap_12
XTAP_TAPCELL_ROW_3_110 VGND VPWR sky130_fd_sc_hd__tapvpwrvgnd_1
XTAP_TAPCELL_ROW_26_256 VGND VPWR sky130_fd_sc_hd__tapvpwrvgnd_1
XFILLER_39_309 VGND VGND VPWR VPWR sky130_fd_sc_hd__decap_4
XTAP_TAPCELL_ROW_17_201 VGND VPWR sky130_fd_sc_hd__tapvpwrvgnd_1
XFILLER_30_264 VGND VGND VPWR VPWR sky130_fd_sc_hd__decap_6
X_0704_ _1093_/A _1448_/Q VGND VGND VPWR VPWR _0705_/B sky130_fd_sc_hd__nand2_1
X_0635_ _0639_/A _0635_/B VGND VGND VPWR VPWR _1461_/D sky130_fd_sc_hd__nor2_2
X_1118_ _1136_/B _1117_/Y _1039_/A VGND VGND VPWR VPWR _1119_/B sky130_fd_sc_hd__o21bai_1
X_1049_ _1049_/A _1248_/Q VGND VGND VPWR VPWR _1055_/B sky130_fd_sc_hd__nand2_1
XTAP_TAPCELL_ROW_23_237 VGND VPWR sky130_fd_sc_hd__tapvpwrvgnd_1
XTAP_TAPCELL_ROW_31_292 VGND VPWR sky130_fd_sc_hd__tapvpwrvgnd_1
XFILLER_0_113 VGND VGND VPWR VPWR sky130_fd_sc_hd__decap_12
XFILLER_29_364 VGND VGND VPWR VPWR sky130_fd_sc_hd__decap_12
XFILLER_12_253 VGND VGND VPWR VPWR sky130_fd_sc_hd__fill_2
XFILLER_8_246 VGND VGND VPWR VPWR sky130_fd_sc_hd__decap_6
XTAP_TAPCELL_ROW_37_329 VGND VPWR sky130_fd_sc_hd__tapvpwrvgnd_1
XPHY_EDGE_ROW_17_Left_57 VGND VGND VPWR VPWR sky130_fd_sc_hd__decap_3
XTAP_TAPCELL_ROW_20_218 VGND VPWR sky130_fd_sc_hd__tapvpwrvgnd_1
X_0618_ _0618_/A VGND VGND VPWR VPWR _1468_/D sky130_fd_sc_hd__buf_2
XFILLER_5_205 VGND VGND VPWR VPWR sky130_fd_sc_hd__decap_6
XFILLER_17_312 VGND VGND VPWR VPWR sky130_fd_sc_hd__fill_1
XFILLER_32_315 VGND VGND VPWR VPWR sky130_fd_sc_hd__fill_1
X_1383_ clkload1/A _1415_/D _1391_/DE VGND VGND VPWR VPWR _1383_/Q sky130_fd_sc_hd__edfxtp_1
X_1452_ _1456_/CLK _1452_/D _1453_/DE VGND VGND VPWR VPWR _1452_/Q sky130_fd_sc_hd__edfxtp_1
XFILLER_23_337 VGND VGND VPWR VPWR sky130_fd_sc_hd__decap_4
XFILLER_1_263 VGND VGND VPWR VPWR sky130_fd_sc_hd__fill_1
X_0952_ _0952_/A _0952_/B VGND VGND VPWR VPWR _0952_/Y sky130_fd_sc_hd__nand2_1
X_0883_ _0932_/A _1202_/Q VGND VGND VPWR VPWR _0885_/A sky130_fd_sc_hd__nand2_1
X_1366_ clkload4/A _1414_/D _1375_/DE VGND VGND VPWR VPWR _1366_/Q sky130_fd_sc_hd__edfxtp_1
X_1435_ _1469_/CLK _1451_/D _1437_/DE VGND VGND VPWR VPWR _1435_/Q sky130_fd_sc_hd__edfxtp_1
X_1297_ clkload9/A _1441_/D _0625_/B VGND VGND VPWR VPWR _1297_/Q sky130_fd_sc_hd__edfxtp_1
XFILLER_36_42 VGND VGND VPWR VPWR sky130_fd_sc_hd__fill_2
XFILLER_14_101 VGND VGND VPWR VPWR sky130_fd_sc_hd__decap_12
XFILLER_6_377 VGND VGND VPWR VPWR sky130_fd_sc_hd__fill_1
XFILLER_6_355 VGND VGND VPWR VPWR sky130_fd_sc_hd__decap_8
X_1220_ clkload6/A _1412_/D _1229_/DE VGND VGND VPWR VPWR _1220_/Q sky130_fd_sc_hd__edfxtp_1
X_1151_ _0764_/A _1150_/Y _0858_/B VGND VGND VPWR VPWR _1152_/A sky130_fd_sc_hd__o21a_1
X_1082_ _1082_/A _1233_/Q VGND VGND VPWR VPWR _1084_/A sky130_fd_sc_hd__nand2_1
X_0935_ _0998_/A _1228_/Q VGND VGND VPWR VPWR _0936_/B sky130_fd_sc_hd__nand2_1
X_0866_ _1120_/A _1205_/Q VGND VGND VPWR VPWR _0867_/B sky130_fd_sc_hd__nand2_1
XTAP_TAPCELL_ROW_15_184 VGND VPWR sky130_fd_sc_hd__tapvpwrvgnd_1
X_0797_ _1093_/A _1352_/Q VGND VGND VPWR VPWR _0799_/B sky130_fd_sc_hd__nand2_1
XFILLER_28_204 VGND VGND VPWR VPWR sky130_fd_sc_hd__fill_1
X_1349_ clkload3/A _1413_/D _1357_/DE VGND VGND VPWR VPWR _1349_/Q sky130_fd_sc_hd__edfxtp_1
X_1418_ clkload2/A _1418_/D _1421_/DE VGND VGND VPWR VPWR _1418_/Q sky130_fd_sc_hd__edfxtp_1
XFILLER_22_55 VGND VGND VPWR VPWR sky130_fd_sc_hd__decap_6
XPHY_EDGE_ROW_5_Left_45 VGND VGND VPWR VPWR sky130_fd_sc_hd__decap_3
XTAP_TAPCELL_ROW_6_130 VGND VPWR sky130_fd_sc_hd__tapvpwrvgnd_1
XFILLER_19_215 VGND VGND VPWR VPWR sky130_fd_sc_hd__decap_8
XFILLER_19_237 VGND VGND VPWR VPWR sky130_fd_sc_hd__fill_1
XTAP_TAPCELL_ROW_29_276 VGND VPWR sky130_fd_sc_hd__tapvpwrvgnd_1
X_0720_ _1063_/A _1403_/Q _1082_/A _1393_/Q _0719_/Y VGND VGND VPWR VPWR _0738_/A
+ sky130_fd_sc_hd__a221oi_2
XTAP_TAPCELL_ROW_12_165 VGND VPWR sky130_fd_sc_hd__tapvpwrvgnd_1
XFILLER_8_79 VGND VGND VPWR VPWR sky130_fd_sc_hd__fill_2
XFILLER_8_46 VGND VGND VPWR VPWR sky130_fd_sc_hd__decap_8
X_0651_ _0651_/A _0651_/B VGND VGND VPWR VPWR _1459_/D sky130_fd_sc_hd__nor2_2
XFILLER_26_3 VGND VGND VPWR VPWR sky130_fd_sc_hd__decap_6
X_1203_ clkload5/A _1411_/D _1212_/DE VGND VGND VPWR VPWR _1203_/Q sky130_fd_sc_hd__edfxtp_1
X_1134_ _1134_/A _1134_/B VGND VGND VPWR VPWR _1135_/A sky130_fd_sc_hd__nand2_1
X_1065_ _1083_/A VGND VGND VPWR VPWR _1079_/A sky130_fd_sc_hd__inv_4
X_0918_ _1079_/A _1223_/Q VGND VGND VPWR VPWR _0919_/B sky130_fd_sc_hd__nand2_1
X_0849_ _1376_/Q _1049_/A _1076_/X _1383_/Q VGND VGND VPWR VPWR _0850_/D sky130_fd_sc_hd__a22oi_1
XFILLER_17_55 VGND VGND VPWR VPWR sky130_fd_sc_hd__fill_1
XTAP_TAPCELL_ROW_3_111 VGND VPWR sky130_fd_sc_hd__tapvpwrvgnd_1
XFILLER_24_251 VGND VGND VPWR VPWR sky130_fd_sc_hd__fill_1
XTAP_TAPCELL_ROW_26_257 VGND VPWR sky130_fd_sc_hd__tapvpwrvgnd_1
XFILLER_3_122 VGND VGND VPWR VPWR sky130_fd_sc_hd__decap_12
XFILLER_3_177 VGND VGND VPWR VPWR sky130_fd_sc_hd__fill_1
XFILLER_15_273 VGND VGND VPWR VPWR sky130_fd_sc_hd__decap_6
XTAP_TAPCELL_ROW_17_202 VGND VPWR sky130_fd_sc_hd__tapvpwrvgnd_1
Xclkbuf_leaf_10_clk clkload0/A VGND VGND VPWR VPWR _1469_/CLK sky130_fd_sc_hd__clkbuf_16
X_0703_ _1092_/A _1449_/Q VGND VGND VPWR VPWR _0705_/A sky130_fd_sc_hd__nand2_1
X_0634_ _0634_/A _0634_/B VGND VGND VPWR VPWR _0635_/B sky130_fd_sc_hd__nor2_1
X_1117_ _1117_/A _1157_/B VGND VGND VPWR VPWR _1117_/Y sky130_fd_sc_hd__nor2_1
XFILLER_21_221 VGND VGND VPWR VPWR sky130_fd_sc_hd__decap_3
X_1048_ _1048_/A _1048_/B VGND VGND VPWR VPWR _1055_/A sky130_fd_sc_hd__nor2_1
XTAP_TAPCELL_ROW_23_238 VGND VPWR sky130_fd_sc_hd__tapvpwrvgnd_1
XPHY_EDGE_ROW_3_Right_3 VGND VGND VPWR VPWR sky130_fd_sc_hd__decap_3
XTAP_TAPCELL_ROW_31_293 VGND VPWR sky130_fd_sc_hd__tapvpwrvgnd_1
XFILLER_0_125 VGND VGND VPWR VPWR sky130_fd_sc_hd__decap_12
XFILLER_0_169 VGND VGND VPWR VPWR sky130_fd_sc_hd__decap_8
XFILLER_29_321 VGND VGND VPWR VPWR sky130_fd_sc_hd__decap_12
Xclkbuf_1_1__f_clk clkbuf_0_clk/X VGND VGND VPWR VPWR clkload0/A sky130_fd_sc_hd__clkbuf_16
XFILLER_29_376 VGND VGND VPWR VPWR sky130_fd_sc_hd__fill_2
XTAP_TAPCELL_ROW_20_219 VGND VPWR sky130_fd_sc_hd__tapvpwrvgnd_1
X_0617_ hold122/X _1259_/DE _0651_/A VGND VGND VPWR VPWR _0618_/A sky130_fd_sc_hd__o21ba_2
XFILLER_26_368 VGND VGND VPWR VPWR sky130_fd_sc_hd__decap_8
XFILLER_14_45 VGND VGND VPWR VPWR sky130_fd_sc_hd__decap_12
XFILLER_5_217 VGND VGND VPWR VPWR sky130_fd_sc_hd__decap_6
XFILLER_29_151 VGND VGND VPWR VPWR sky130_fd_sc_hd__decap_6
XFILLER_39_53 VGND VGND VPWR VPWR sky130_fd_sc_hd__decap_3
XPHY_EDGE_ROW_34_Left_74 VGND VGND VPWR VPWR sky130_fd_sc_hd__decap_3
X_1382_ clkload1/A _1414_/D _1389_/DE VGND VGND VPWR VPWR _1382_/Q sky130_fd_sc_hd__edfxtp_1
X_1451_ clkload5/A _1451_/D _1455_/DE VGND VGND VPWR VPWR _1451_/Q sky130_fd_sc_hd__edfxtp_1
XFILLER_35_132 VGND VGND VPWR VPWR sky130_fd_sc_hd__fill_2
XFILLER_35_176 VGND VGND VPWR VPWR sky130_fd_sc_hd__decap_4
XFILLER_14_305 VGND VGND VPWR VPWR sky130_fd_sc_hd__decap_3
XFILLER_25_11 VGND VGND VPWR VPWR sky130_fd_sc_hd__decap_3
XFILLER_1_297 VGND VGND VPWR VPWR sky130_fd_sc_hd__fill_1
XFILLER_2_59 VGND VGND VPWR VPWR sky130_fd_sc_hd__fill_1
X_0951_ _1324_/Q _1090_/B VGND VGND VPWR VPWR _0952_/B sky130_fd_sc_hd__nand2_1
X_0882_ _0882_/A _0882_/B VGND VGND VPWR VPWR _0891_/A sky130_fd_sc_hd__nor2_1
X_1296_ clkload9/A _1440_/D _0625_/B VGND VGND VPWR VPWR _1296_/Q sky130_fd_sc_hd__edfxtp_1
X_1365_ clkload4/A _1413_/D _1375_/DE VGND VGND VPWR VPWR _1365_/Q sky130_fd_sc_hd__edfxtp_1
X_1434_ clkload5/A _1450_/D _1434_/DE VGND VGND VPWR VPWR _1434_/Q sky130_fd_sc_hd__edfxtp_1
XFILLER_11_319 VGND VGND VPWR VPWR sky130_fd_sc_hd__decap_8
XFILLER_23_124 VGND VGND VPWR VPWR sky130_fd_sc_hd__decap_6
XFILLER_11_57 VGND VGND VPWR VPWR sky130_fd_sc_hd__fill_2
XFILLER_14_113 VGND VGND VPWR VPWR sky130_fd_sc_hd__decap_3
XFILLER_22_190 VGND VGND VPWR VPWR sky130_fd_sc_hd__fill_1
XTAP_TAPCELL_ROW_9_150 VGND VPWR sky130_fd_sc_hd__tapvpwrvgnd_1
X_1150_ _1150_/A _1150_/B VGND VGND VPWR VPWR _1150_/Y sky130_fd_sc_hd__nor2_1
X_1081_ _1081_/A _1081_/B VGND VGND VPWR VPWR _1085_/A sky130_fd_sc_hd__nand2_1
XFILLER_20_116 VGND VGND VPWR VPWR sky130_fd_sc_hd__decap_8
X_0934_ _0934_/A _1227_/Q VGND VGND VPWR VPWR _0936_/A sky130_fd_sc_hd__nand2_1
X_0865_ _1187_/B _0909_/B VGND VGND VPWR VPWR _0865_/Y sky130_fd_sc_hd__nor2_1
XTAP_TAPCELL_ROW_15_185 VGND VPWR sky130_fd_sc_hd__tapvpwrvgnd_1
XPHY_EDGE_ROW_21_Left_61 VGND VGND VPWR VPWR sky130_fd_sc_hd__decap_3
XFILLER_9_183 VGND VGND VPWR VPWR sky130_fd_sc_hd__fill_2
X_1417_ clkload7/A _1417_/D _1421_/DE VGND VGND VPWR VPWR _1417_/Q sky130_fd_sc_hd__edfxtp_1
X_0796_ _1045_/A _1353_/Q VGND VGND VPWR VPWR _0799_/A sky130_fd_sc_hd__nand2_1
XFILLER_28_238 VGND VGND VPWR VPWR sky130_fd_sc_hd__decap_8
X_1279_ _1468_/CLK _1455_/D _0629_/B VGND VGND VPWR VPWR _1279_/Q sky130_fd_sc_hd__edfxtp_1
X_1348_ clkload3/A _1412_/D _0641_/B VGND VGND VPWR VPWR _1348_/Q sky130_fd_sc_hd__edfxtp_1
XFILLER_36_282 VGND VGND VPWR VPWR sky130_fd_sc_hd__fill_2
XFILLER_3_337 VGND VGND VPWR VPWR sky130_fd_sc_hd__decap_4
XTAP_TAPCELL_ROW_6_131 VGND VPWR sky130_fd_sc_hd__tapvpwrvgnd_1
XTAP_TAPCELL_ROW_29_277 VGND VPWR sky130_fd_sc_hd__tapvpwrvgnd_1
XTAP_TAPCELL_ROW_12_166 VGND VPWR sky130_fd_sc_hd__tapvpwrvgnd_1
X_0650_ _0650_/A _0650_/B VGND VGND VPWR VPWR _0651_/B sky130_fd_sc_hd__nor2_1
XFILLER_19_3 VGND VGND VPWR VPWR sky130_fd_sc_hd__decap_12
XFILLER_25_219 VGND VGND VPWR VPWR sky130_fd_sc_hd__decap_4
X_1202_ clkload6/A _1410_/D _0619_/B VGND VGND VPWR VPWR _1202_/Q sky130_fd_sc_hd__edfxtp_1
X_1133_ _1133_/A _1133_/B VGND VGND VPWR VPWR _1134_/A sky130_fd_sc_hd__nand2_1
X_1064_ _1060_/B _1060_/A _1063_/Y VGND VGND VPWR VPWR _1073_/A sky130_fd_sc_hd__o21ai_1
X_0917_ _1120_/A _1221_/Q VGND VGND VPWR VPWR _0919_/A sky130_fd_sc_hd__nand2_1
X_0848_ _0923_/A _1390_/Q VGND VGND VPWR VPWR _0850_/C sky130_fd_sc_hd__nand2_1
X_0779_ _0902_/A _1338_/Q _0943_/X _1331_/Q VGND VGND VPWR VPWR _0779_/X sky130_fd_sc_hd__a22o_1
XTAP_TAPCELL_ROW_26_258 VGND VPWR sky130_fd_sc_hd__tapvpwrvgnd_1
XFILLER_24_285 VGND VGND VPWR VPWR sky130_fd_sc_hd__decap_3
XFILLER_24_296 VGND VGND VPWR VPWR sky130_fd_sc_hd__decap_6
XFILLER_3_134 VGND VGND VPWR VPWR sky130_fd_sc_hd__decap_4
X_0702_ _0702_/A _0702_/B VGND VGND VPWR VPWR _0706_/A sky130_fd_sc_hd__nand2_1
X_0633_ _0651_/A _0633_/B VGND VGND VPWR VPWR _1466_/D sky130_fd_sc_hd__nor2_1
XFILLER_0_81 VGND VGND VPWR VPWR sky130_fd_sc_hd__decap_3
XFILLER_38_377 VGND VGND VPWR VPWR sky130_fd_sc_hd__fill_1
X_1116_ _1137_/B VGND VGND VPWR VPWR _1117_/A sky130_fd_sc_hd__inv_1
X_1047_ _1047_/A _1047_/B VGND VGND VPWR VPWR _1048_/B sky130_fd_sc_hd__nand2_1
XTAP_TAPCELL_ROW_23_239 VGND VPWR sky130_fd_sc_hd__tapvpwrvgnd_1
XFILLER_9_90 VGND VGND VPWR VPWR sky130_fd_sc_hd__decap_12
XFILLER_0_137 VGND VGND VPWR VPWR sky130_fd_sc_hd__decap_3
XFILLER_28_11 VGND VGND VPWR VPWR sky130_fd_sc_hd__fill_1
XFILLER_29_333 VGND VGND VPWR VPWR sky130_fd_sc_hd__decap_3
XTAP_TAPCELL_ROW_39_350 VGND VPWR sky130_fd_sc_hd__tapvpwrvgnd_1
XFILLER_35_314 VGND VGND VPWR VPWR sky130_fd_sc_hd__fill_2
XPHY_EDGE_ROW_13_Right_13 VGND VGND VPWR VPWR sky130_fd_sc_hd__decap_3
XPHY_EDGE_ROW_22_Right_22 VGND VGND VPWR VPWR sky130_fd_sc_hd__decap_3
X_0616_ _1042_/A _0765_/B VGND VGND VPWR VPWR _0616_/Y sky130_fd_sc_hd__nor2_1
XFILLER_7_281 VGND VGND VPWR VPWR sky130_fd_sc_hd__decap_4
XPHY_EDGE_ROW_31_Right_31 VGND VGND VPWR VPWR sky130_fd_sc_hd__decap_3
XTAP_TAPCELL_ROW_36_320 VGND VPWR sky130_fd_sc_hd__tapvpwrvgnd_1
XFILLER_14_57 VGND VGND VPWR VPWR sky130_fd_sc_hd__decap_3
XFILLER_30_45 VGND VGND VPWR VPWR sky130_fd_sc_hd__fill_1
XFILLER_32_328 VGND VGND VPWR VPWR sky130_fd_sc_hd__decap_3
X_1450_ clkload5/A _1450_/D _1453_/DE VGND VGND VPWR VPWR _1450_/Q sky130_fd_sc_hd__edfxtp_1
X_1381_ clkload1/A _1413_/D _1391_/DE VGND VGND VPWR VPWR _1381_/Q sky130_fd_sc_hd__edfxtp_1
XFILLER_35_111 VGND VGND VPWR VPWR sky130_fd_sc_hd__fill_1
XTAP_TAPCELL_ROW_33_301 VGND VPWR sky130_fd_sc_hd__tapvpwrvgnd_1
XFILLER_14_317 VGND VGND VPWR VPWR sky130_fd_sc_hd__decap_12
XFILLER_25_78 VGND VGND VPWR VPWR sky130_fd_sc_hd__decap_8
XFILLER_20_309 VGND VGND VPWR VPWR sky130_fd_sc_hd__decap_12
XFILLER_32_169 VGND VGND VPWR VPWR sky130_fd_sc_hd__decap_12
X_0950_ _1070_/B _1325_/Q VGND VGND VPWR VPWR _0952_/A sky130_fd_sc_hd__nand2_1
X_0881_ _0881_/A _0881_/B VGND VGND VPWR VPWR _0882_/B sky130_fd_sc_hd__nand2_1
XFILLER_9_321 VGND VGND VPWR VPWR sky130_fd_sc_hd__decap_12
X_1433_ _1456_/CLK _1449_/D _1437_/DE VGND VGND VPWR VPWR _1433_/Q sky130_fd_sc_hd__edfxtp_1
X_1295_ _1466_/CLK _1455_/D _1295_/DE VGND VGND VPWR VPWR _1295_/Q sky130_fd_sc_hd__edfxtp_1
X_1364_ clkload4/A _1412_/D _1375_/DE VGND VGND VPWR VPWR _1364_/Q sky130_fd_sc_hd__edfxtp_1
XFILLER_23_158 VGND VGND VPWR VPWR sky130_fd_sc_hd__decap_8
XFILLER_23_169 VGND VGND VPWR VPWR sky130_fd_sc_hd__decap_8
X_1080_ _1080_/A _1232_/Q VGND VGND VPWR VPWR _1081_/B sky130_fd_sc_hd__nand2_1
XFILLER_20_139 VGND VGND VPWR VPWR sky130_fd_sc_hd__fill_1
XTAP_TAPCELL_ROW_15_186 VGND VPWR sky130_fd_sc_hd__tapvpwrvgnd_1
X_0933_ _0933_/A _0933_/B VGND VGND VPWR VPWR _0937_/A sky130_fd_sc_hd__nand2_1
X_0864_ _0934_/A _1211_/Q VGND VGND VPWR VPWR _0867_/A sky130_fd_sc_hd__nand2_1
X_0795_ _0902_/A _1354_/Q _1049_/A _1344_/Q _0794_/Y VGND VGND VPWR VPWR _0807_/B
+ sky130_fd_sc_hd__a221oi_2
X_1347_ clkload3/A _1411_/D _0641_/B VGND VGND VPWR VPWR _1347_/Q sky130_fd_sc_hd__edfxtp_1
X_1416_ clkload7/A _1416_/D _1421_/DE VGND VGND VPWR VPWR _1416_/Q sky130_fd_sc_hd__edfxtp_1
X_1278_ _1468_/CLK _1454_/D _0629_/B VGND VGND VPWR VPWR _1278_/Q sky130_fd_sc_hd__edfxtp_1
XFILLER_11_117 VGND VGND VPWR VPWR sky130_fd_sc_hd__fill_1
XTAP_TAPCELL_ROW_29_278 VGND VPWR sky130_fd_sc_hd__tapvpwrvgnd_1
XFILLER_10_161 VGND VGND VPWR VPWR sky130_fd_sc_hd__fill_1
XTAP_TAPCELL_ROW_12_167 VGND VPWR sky130_fd_sc_hd__tapvpwrvgnd_1
X_1201_ clkload6/A _1441_/D _1212_/DE VGND VGND VPWR VPWR _1201_/Q sky130_fd_sc_hd__edfxtp_1
X_1132_ _0940_/A _1128_/B _1127_/A VGND VGND VPWR VPWR _1133_/A sky130_fd_sc_hd__o21bai_1
X_1063_ _1063_/A _1259_/Q VGND VGND VPWR VPWR _1063_/Y sky130_fd_sc_hd__nand2_1
XFILLER_33_297 VGND VGND VPWR VPWR sky130_fd_sc_hd__fill_1
X_0916_ _1049_/A _0916_/B VGND VGND VPWR VPWR _0921_/A sky130_fd_sc_hd__nor2_1
X_0847_ _0847_/A VGND VGND VPWR VPWR _0850_/A sky130_fd_sc_hd__inv_1
X_0778_ _1109_/A _1332_/Q _0932_/A _1330_/Q _0777_/Y VGND VGND VPWR VPWR _0786_/B
+ sky130_fd_sc_hd__a221oi_1
XFILLER_24_253 VGND VGND VPWR VPWR sky130_fd_sc_hd__decap_6
XTAP_TAPCELL_ROW_26_259 VGND VPWR sky130_fd_sc_hd__tapvpwrvgnd_1
X_0701_ _1090_/B _1452_/Q VGND VGND VPWR VPWR _0702_/B sky130_fd_sc_hd__nand2_1
X_0632_ _1178_/Y _1042_/B VGND VGND VPWR VPWR _0632_/Y sky130_fd_sc_hd__nor2_2
XFILLER_0_93 VGND VGND VPWR VPWR sky130_fd_sc_hd__decap_12
X_1115_ _1135_/B _1134_/B _1137_/B _1136_/B _1130_/A VGND VGND VPWR VPWR _1119_/A
+ sky130_fd_sc_hd__o2111ai_1
X_1046_ _1046_/A _1256_/Q VGND VGND VPWR VPWR _1047_/B sky130_fd_sc_hd__nand2_1
XFILLER_0_105 VGND VGND VPWR VPWR sky130_fd_sc_hd__decap_4
XTAP_TAPCELL_ROW_39_351 VGND VPWR sky130_fd_sc_hd__tapvpwrvgnd_1
XTAP_TAPCELL_ROW_39_340 VGND VPWR sky130_fd_sc_hd__tapvpwrvgnd_1
XFILLER_39_109 VGND VGND VPWR VPWR sky130_fd_sc_hd__decap_3
X_0615_ _0613_/Y _0614_/Y _0651_/A VGND VGND VPWR VPWR _1469_/D sky130_fd_sc_hd__a21oi_1
X_1029_ _1100_/A _1306_/Q _0943_/X _1299_/Q VGND VGND VPWR VPWR _1029_/X sky130_fd_sc_hd__a22o_1
XTAP_TAPCELL_ROW_36_321 VGND VPWR sky130_fd_sc_hd__tapvpwrvgnd_1
XFILLER_32_307 VGND VGND VPWR VPWR sky130_fd_sc_hd__fill_1
XFILLER_4_263 VGND VGND VPWR VPWR sky130_fd_sc_hd__fill_1
X_1380_ clkload1/A _1412_/D _1391_/DE VGND VGND VPWR VPWR _1380_/Q sky130_fd_sc_hd__edfxtp_1
XFILLER_23_329 VGND VGND VPWR VPWR sky130_fd_sc_hd__decap_6
XTAP_TAPCELL_ROW_33_302 VGND VPWR sky130_fd_sc_hd__tapvpwrvgnd_1
XFILLER_14_329 VGND VGND VPWR VPWR sky130_fd_sc_hd__fill_1
XFILLER_26_178 VGND VGND VPWR VPWR sky130_fd_sc_hd__fill_2
XFILLER_25_57 VGND VGND VPWR VPWR sky130_fd_sc_hd__fill_1
XFILLER_9_3 VGND VGND VPWR VPWR sky130_fd_sc_hd__fill_2
X_0880_ _1204_/Q _1109_/A VGND VGND VPWR VPWR _0881_/B sky130_fd_sc_hd__nand2_1
XFILLER_9_377 VGND VGND VPWR VPWR sky130_fd_sc_hd__fill_1
XFILLER_9_333 VGND VGND VPWR VPWR sky130_fd_sc_hd__decap_3
X_1363_ clkload4/A _1411_/D _0634_/B VGND VGND VPWR VPWR _1363_/Q sky130_fd_sc_hd__edfxtp_1
X_1432_ _1456_/CLK _1448_/D _1437_/DE VGND VGND VPWR VPWR _1432_/Q sky130_fd_sc_hd__edfxtp_1
X_1294_ _1466_/CLK _1454_/D _1295_/DE VGND VGND VPWR VPWR _1294_/Q sky130_fd_sc_hd__edfxtp_1
XFILLER_11_48 VGND VGND VPWR VPWR sky130_fd_sc_hd__decap_8
XFILLER_39_281 VGND VGND VPWR VPWR sky130_fd_sc_hd__decap_8
XFILLER_39_292 VGND VGND VPWR VPWR sky130_fd_sc_hd__decap_12
XFILLER_10_321 VGND VGND VPWR VPWR sky130_fd_sc_hd__decap_12
XFILLER_10_365 VGND VGND VPWR VPWR sky130_fd_sc_hd__decap_12
XFILLER_22_170 VGND VGND VPWR VPWR sky130_fd_sc_hd__decap_8
XFILLER_22_181 VGND VGND VPWR VPWR sky130_fd_sc_hd__fill_1
X_0932_ _0932_/A VGND VGND VPWR VPWR _1099_/A sky130_fd_sc_hd__inv_8
XTAP_TAPCELL_ROW_15_187 VGND VPWR sky130_fd_sc_hd__tapvpwrvgnd_1
X_0863_ _0863_/A _0863_/B VGND VGND VPWR VPWR _0868_/A sky130_fd_sc_hd__nand2_1
X_0794_ _0794_/A _0794_/B VGND VGND VPWR VPWR _0794_/Y sky130_fd_sc_hd__nand2_1
XFILLER_28_229 VGND VGND VPWR VPWR sky130_fd_sc_hd__decap_6
X_1346_ clkload3/A _1410_/D _0641_/B VGND VGND VPWR VPWR _1346_/Q sky130_fd_sc_hd__edfxtp_1
X_1415_ clkload1/A _1415_/D _1423_/DE VGND VGND VPWR VPWR _1415_/Q sky130_fd_sc_hd__edfxtp_1
X_1277_ clkload8/A _1453_/D _1277_/DE VGND VGND VPWR VPWR _1277_/Q sky130_fd_sc_hd__edfxtp_1
XFILLER_27_262 VGND VGND VPWR VPWR sky130_fd_sc_hd__decap_12
XTAP_TAPCELL_ROW_29_279 VGND VPWR sky130_fd_sc_hd__tapvpwrvgnd_1
XTAP_TAPCELL_ROW_12_168 VGND VPWR sky130_fd_sc_hd__tapvpwrvgnd_1
XFILLER_6_144 VGND VGND VPWR VPWR sky130_fd_sc_hd__decap_12
X_1200_ clkload6/A _1408_/D _0619_/B VGND VGND VPWR VPWR _1200_/Q sky130_fd_sc_hd__edfxtp_1
X_1131_ input7/X _1131_/B VGND VGND VPWR VPWR _1131_/Y sky130_fd_sc_hd__nor2_1
X_1062_ _1062_/A _1062_/B VGND VGND VPWR VPWR _1074_/A sky130_fd_sc_hd__nor2_1
XFILLER_33_265 VGND VGND VPWR VPWR sky130_fd_sc_hd__decap_12
Xclkbuf_leaf_13_clk clkbuf_leaf_4_clk/A VGND VGND VPWR VPWR clkload6/A sky130_fd_sc_hd__clkbuf_16
X_0915_ _1217_/Q VGND VGND VPWR VPWR _0916_/B sky130_fd_sc_hd__inv_1
X_0846_ _1120_/A _1381_/Q _1106_/A _1391_/Q VGND VGND VPWR VPWR _0847_/A sky130_fd_sc_hd__a22o_1
X_0777_ _0923_/A _0774_/Y _0775_/Y VGND VGND VPWR VPWR _0777_/Y sky130_fd_sc_hd__o21ai_0
X_1329_ clkload4/A _1409_/D _0638_/B VGND VGND VPWR VPWR _1329_/Q sky130_fd_sc_hd__edfxtp_1
XFILLER_24_265 VGND VGND VPWR VPWR sky130_fd_sc_hd__decap_12
XFILLER_33_57 VGND VGND VPWR VPWR sky130_fd_sc_hd__fill_1
XPHY_EDGE_ROW_9_Left_49 VGND VGND VPWR VPWR sky130_fd_sc_hd__decap_3
XFILLER_30_224 VGND VGND VPWR VPWR sky130_fd_sc_hd__decap_4
X_0700_ _1089_/A _1453_/Q VGND VGND VPWR VPWR _0702_/A sky130_fd_sc_hd__nand2_1
X_0631_ _0631_/A _0631_/B VGND VGND VPWR VPWR _0633_/B sky130_fd_sc_hd__nor2_1
XFILLER_24_3 VGND VGND VPWR VPWR sky130_fd_sc_hd__decap_8
Xclkbuf_leaf_2_clk clkbuf_leaf_4_clk/A VGND VGND VPWR VPWR clkload3/A sky130_fd_sc_hd__clkbuf_16
X_1114_ _1114_/A _1114_/B VGND VGND VPWR VPWR _1126_/A sky130_fd_sc_hd__nor2_2
X_1045_ _1045_/A _1257_/Q VGND VGND VPWR VPWR _1047_/A sky130_fd_sc_hd__nand2_1
X_0829_ _1046_/A _1368_/Q VGND VGND VPWR VPWR _0829_/Y sky130_fd_sc_hd__nand2_1
XFILLER_9_81 VGND VGND VPWR VPWR sky130_fd_sc_hd__decap_6
XTAP_TAPCELL_ROW_39_352 VGND VPWR sky130_fd_sc_hd__tapvpwrvgnd_1
XTAP_TAPCELL_ROW_39_341 VGND VPWR sky130_fd_sc_hd__tapvpwrvgnd_1
XFILLER_12_202 VGND VGND VPWR VPWR sky130_fd_sc_hd__decap_4
XTAP_TAPCELL_ROW_22_230 VGND VPWR sky130_fd_sc_hd__tapvpwrvgnd_1
XFILLER_8_228 VGND VGND VPWR VPWR sky130_fd_sc_hd__decap_3
X_0614_ _0614_/A VGND VGND VPWR VPWR _0614_/Y sky130_fd_sc_hd__inv_2
XPHY_EDGE_ROW_7_Right_7 VGND VGND VPWR VPWR sky130_fd_sc_hd__decap_3
XTAP_TAPCELL_ROW_36_322 VGND VPWR sky130_fd_sc_hd__tapvpwrvgnd_1
XFILLER_14_15 VGND VGND VPWR VPWR sky130_fd_sc_hd__decap_12
X_1028_ _1103_/A _1300_/Q _1104_/A _1298_/Q _1027_/Y VGND VGND VPWR VPWR _1037_/B
+ sky130_fd_sc_hd__a221oi_1
XFILLER_39_45 VGND VGND VPWR VPWR sky130_fd_sc_hd__decap_8
XFILLER_29_165 VGND VGND VPWR VPWR sky130_fd_sc_hd__decap_3
XFILLER_4_231 VGND VGND VPWR VPWR sky130_fd_sc_hd__fill_1
XFILLER_23_319 VGND VGND VPWR VPWR sky130_fd_sc_hd__decap_3
XTAP_TAPCELL_ROW_33_303 VGND VPWR sky130_fd_sc_hd__tapvpwrvgnd_1
XPHY_EDGE_ROW_38_Left_78 VGND VGND VPWR VPWR sky130_fd_sc_hd__decap_3
XFILLER_1_234 VGND VGND VPWR VPWR sky130_fd_sc_hd__fill_2
XFILLER_17_113 VGND VGND VPWR VPWR sky130_fd_sc_hd__decap_6
XFILLER_1_289 VGND VGND VPWR VPWR sky130_fd_sc_hd__decap_8
XFILLER_13_363 VGND VGND VPWR VPWR sky130_fd_sc_hd__decap_12
XFILLER_32_127 VGND VGND VPWR VPWR sky130_fd_sc_hd__decap_12
X_1293_ _1468_/CLK _1453_/D _1295_/DE VGND VGND VPWR VPWR _1293_/Q sky130_fd_sc_hd__edfxtp_1
X_1362_ clkload4/A _1410_/D _1375_/DE VGND VGND VPWR VPWR _1362_/Q sky130_fd_sc_hd__edfxtp_1
X_1431_ _1456_/CLK _1447_/D _1439_/DE VGND VGND VPWR VPWR _1431_/Q sky130_fd_sc_hd__edfxtp_1
XFILLER_10_377 VGND VGND VPWR VPWR sky130_fd_sc_hd__fill_1
XFILLER_13_160 VGND VGND VPWR VPWR sky130_fd_sc_hd__fill_2
X_0931_ _0931_/A input2/X _0931_/C VGND VGND VPWR VPWR _1042_/B sky130_fd_sc_hd__nand3_1
X_0862_ _0902_/A _1210_/Q VGND VGND VPWR VPWR _0863_/B sky130_fd_sc_hd__nand2_1
XTAP_TAPCELL_ROW_15_188 VGND VPWR sky130_fd_sc_hd__tapvpwrvgnd_1
XFILLER_9_175 VGND VGND VPWR VPWR sky130_fd_sc_hd__decap_8
XFILLER_9_142 VGND VGND VPWR VPWR sky130_fd_sc_hd__fill_1
XFILLER_9_120 VGND VGND VPWR VPWR sky130_fd_sc_hd__fill_2
X_0793_ _0998_/A _1356_/Q VGND VGND VPWR VPWR _0794_/B sky130_fd_sc_hd__nand2_1
XFILLER_3_61 VGND VGND VPWR VPWR sky130_fd_sc_hd__fill_1
X_1276_ clkload8/A _1452_/D _1277_/DE VGND VGND VPWR VPWR _1276_/Q sky130_fd_sc_hd__edfxtp_1
X_1345_ clkload3/A _1409_/D _0641_/B VGND VGND VPWR VPWR _1345_/Q sky130_fd_sc_hd__edfxtp_1
X_1414_ clkload1/A _1414_/D _1423_/DE VGND VGND VPWR VPWR _1414_/Q sky130_fd_sc_hd__edfxtp_1
XFILLER_22_37 VGND VGND VPWR VPWR sky130_fd_sc_hd__fill_1
XFILLER_27_274 VGND VGND VPWR VPWR sky130_fd_sc_hd__decap_6
XFILLER_10_141 VGND VGND VPWR VPWR sky130_fd_sc_hd__decap_12
XTAP_TAPCELL_ROW_12_169 VGND VPWR sky130_fd_sc_hd__tapvpwrvgnd_1
XFILLER_6_101 VGND VGND VPWR VPWR sky130_fd_sc_hd__decap_6
XFILLER_6_156 VGND VGND VPWR VPWR sky130_fd_sc_hd__fill_1
XFILLER_2_362 VGND VGND VPWR VPWR sky130_fd_sc_hd__fill_2
X_1130_ _1130_/A _1157_/A VGND VGND VPWR VPWR _1130_/Y sky130_fd_sc_hd__nand2_1
XPHY_EDGE_ROW_25_Left_65 VGND VGND VPWR VPWR sky130_fd_sc_hd__decap_3
XFILLER_18_285 VGND VGND VPWR VPWR sky130_fd_sc_hd__decap_4
XFILLER_33_277 VGND VGND VPWR VPWR sky130_fd_sc_hd__decap_3
X_1061_ _1255_/Q _1056_/Y _1057_/Y _1058_/Y _1060_/Y VGND VGND VPWR VPWR _1062_/B
+ sky130_fd_sc_hd__o2111ai_1
X_0914_ _0914_/A _0914_/B VGND VGND VPWR VPWR _0939_/A sky130_fd_sc_hd__nand2_1
X_0845_ _0836_/Y _0845_/B _0845_/C VGND VGND VPWR VPWR _0855_/A sky130_fd_sc_hd__and3b_1
X_0776_ _0776_/A _0776_/B VGND VGND VPWR VPWR _0776_/Y sky130_fd_sc_hd__nor2_1
XFILLER_17_15 VGND VGND VPWR VPWR sky130_fd_sc_hd__decap_3
X_1328_ clkload4/A _1440_/D _0638_/B VGND VGND VPWR VPWR _1328_/Q sky130_fd_sc_hd__edfxtp_1
X_1259_ _1468_/CLK _1419_/D _1259_/DE VGND VGND VPWR VPWR _1259_/Q sky130_fd_sc_hd__edfxtp_1
XFILLER_24_277 VGND VGND VPWR VPWR sky130_fd_sc_hd__decap_8
XTAP_TAPCELL_ROW_25_250 VGND VPWR sky130_fd_sc_hd__tapvpwrvgnd_1
X_0630_ _0651_/A _0630_/B VGND VGND VPWR VPWR _1467_/D sky130_fd_sc_hd__nor2_2
XFILLER_17_3 VGND VGND VPWR VPWR sky130_fd_sc_hd__decap_12
X_1113_ _1121_/A _1121_/B _1112_/Y VGND VGND VPWR VPWR _1114_/B sky130_fd_sc_hd__nor3b_2
X_1044_ _1044_/A _1468_/Q VGND VGND VPWR VPWR _1048_/A sky130_fd_sc_hd__nand2_1
X_0828_ _1372_/Q _1070_/B VGND VGND VPWR VPWR _0828_/Y sky130_fd_sc_hd__nor2_1
X_0759_ _1093_/A _1416_/Q VGND VGND VPWR VPWR _0759_/Y sky130_fd_sc_hd__nand2_1
XTAP_TAPCELL_ROW_39_342 VGND VPWR sky130_fd_sc_hd__tapvpwrvgnd_1
XTAP_TAPCELL_ROW_22_231 VGND VPWR sky130_fd_sc_hd__tapvpwrvgnd_1
XFILLER_18_80 VGND VGND VPWR VPWR sky130_fd_sc_hd__fill_1
X_0613_ _0613_/A VGND VGND VPWR VPWR _0613_/Y sky130_fd_sc_hd__inv_1
XFILLER_26_306 VGND VGND VPWR VPWR sky130_fd_sc_hd__fill_2
X_1027_ _1060_/B _1025_/Y _1026_/Y VGND VGND VPWR VPWR _1027_/Y sky130_fd_sc_hd__o21ai_0
XTAP_TAPCELL_ROW_36_323 VGND VPWR sky130_fd_sc_hd__tapvpwrvgnd_1
XFILLER_14_27 VGND VGND VPWR VPWR sky130_fd_sc_hd__fill_1
XPHY_EDGE_ROW_12_Left_52 VGND VGND VPWR VPWR sky130_fd_sc_hd__decap_3
XFILLER_17_306 VGND VGND VPWR VPWR sky130_fd_sc_hd__fill_2
XFILLER_29_177 VGND VGND VPWR VPWR sky130_fd_sc_hd__decap_3
XFILLER_39_57 VGND VGND VPWR VPWR sky130_fd_sc_hd__decap_3
XFILLER_32_309 VGND VGND VPWR VPWR sky130_fd_sc_hd__decap_6
XFILLER_20_81 VGND VGND VPWR VPWR sky130_fd_sc_hd__decap_3
XTAP_TAPCELL_ROW_33_304 VGND VPWR sky130_fd_sc_hd__tapvpwrvgnd_1
XFILLER_17_169 VGND VGND VPWR VPWR sky130_fd_sc_hd__fill_2
XFILLER_13_375 VGND VGND VPWR VPWR sky130_fd_sc_hd__decap_3
XFILLER_25_180 VGND VGND VPWR VPWR sky130_fd_sc_hd__fill_2
XFILLER_32_139 VGND VGND VPWR VPWR sky130_fd_sc_hd__fill_1
X_1430_ _1469_/CLK _1446_/D _1439_/DE VGND VGND VPWR VPWR _1430_/Q sky130_fd_sc_hd__edfxtp_1
X_1292_ clkload8/A _1452_/D _1295_/DE VGND VGND VPWR VPWR _1292_/Q sky130_fd_sc_hd__edfxtp_1
X_1361_ _1494_/CLK _1409_/D _0634_/B VGND VGND VPWR VPWR _1361_/Q sky130_fd_sc_hd__edfxtp_1
XFILLER_10_301 VGND VGND VPWR VPWR sky130_fd_sc_hd__decap_6
XFILLER_22_194 VGND VGND VPWR VPWR sky130_fd_sc_hd__fill_2
X_0930_ _0932_/A _1218_/Q VGND VGND VPWR VPWR _0933_/B sky130_fd_sc_hd__nand2_1
X_0861_ _1090_/B _1212_/Q VGND VGND VPWR VPWR _0863_/A sky130_fd_sc_hd__nand2_1
X_0792_ _1070_/B _1357_/Q VGND VGND VPWR VPWR _0794_/A sky130_fd_sc_hd__nand2_1
XTAP_TAPCELL_ROW_15_189 VGND VPWR sky130_fd_sc_hd__tapvpwrvgnd_1
X_1413_ clkload7/A _1413_/D _1423_/DE VGND VGND VPWR VPWR _1413_/Q sky130_fd_sc_hd__edfxtp_1
X_1275_ _1468_/CLK _1451_/D _0629_/B VGND VGND VPWR VPWR _1275_/Q sky130_fd_sc_hd__edfxtp_1
X_1344_ clkload2/A _1408_/D _0641_/B VGND VGND VPWR VPWR _1344_/Q sky130_fd_sc_hd__edfxtp_1
XFILLER_22_49 VGND VGND VPWR VPWR sky130_fd_sc_hd__decap_3
Xfanout100 _1474_/Q VGND VGND VPWR VPWR _1442_/D sky130_fd_sc_hd__clkdlybuf4s50_1
XFILLER_27_231 VGND VGND VPWR VPWR sky130_fd_sc_hd__fill_1
XPHY_EDGE_ROW_29_Right_29 VGND VGND VPWR VPWR sky130_fd_sc_hd__decap_3
XFILLER_10_153 VGND VGND VPWR VPWR sky130_fd_sc_hd__decap_8
XFILLER_10_186 VGND VGND VPWR VPWR sky130_fd_sc_hd__fill_1
XPHY_EDGE_ROW_38_Right_38 VGND VGND VPWR VPWR sky130_fd_sc_hd__decap_3
XFILLER_8_29 VGND VGND VPWR VPWR sky130_fd_sc_hd__fill_2
XFILLER_6_135 VGND VGND VPWR VPWR sky130_fd_sc_hd__fill_1
XFILLER_10_197 VGND VGND VPWR VPWR sky130_fd_sc_hd__fill_2
XPHY_EDGE_ROW_0_Left_40 VGND VGND VPWR VPWR sky130_fd_sc_hd__decap_3
X_1060_ _1060_/A _1060_/B _1262_/Q VGND VGND VPWR VPWR _1060_/Y sky130_fd_sc_hd__nand3_1
XFILLER_18_253 VGND VGND VPWR VPWR sky130_fd_sc_hd__decap_8
XFILLER_33_289 VGND VGND VPWR VPWR sky130_fd_sc_hd__decap_8
XTAP_TAPCELL_ROW_28_270 VGND VPWR sky130_fd_sc_hd__tapvpwrvgnd_1
X_0913_ _0913_/A _0913_/B VGND VGND VPWR VPWR _0914_/B sky130_fd_sc_hd__nor2_1
X_0844_ _0908_/A _1382_/Q _1082_/A _1377_/Q VGND VGND VPWR VPWR _0845_/C sky130_fd_sc_hd__a22oi_1
X_0775_ _0923_/A _1342_/Q VGND VGND VPWR VPWR _0775_/Y sky130_fd_sc_hd__nand2_1
X_1327_ clkload9/A _1455_/D _1327_/DE VGND VGND VPWR VPWR _1327_/Q sky130_fd_sc_hd__edfxtp_1
X_1258_ _1468_/CLK _1418_/D _1259_/DE VGND VGND VPWR VPWR _1258_/Q sky130_fd_sc_hd__edfxtp_1
X_1189_ input2/X input1/X VGND VGND VPWR VPWR _1189_/Y sky130_fd_sc_hd__nand2_1
XFILLER_3_138 VGND VGND VPWR VPWR sky130_fd_sc_hd__fill_1
XTAP_TAPCELL_ROW_25_251 VGND VPWR sky130_fd_sc_hd__tapvpwrvgnd_1
X_1112_ _1130_/A _1133_/B _1155_/A VGND VGND VPWR VPWR _1112_/Y sky130_fd_sc_hd__nand3_2
X_1043_ input5/X _1043_/B VGND VGND VPWR VPWR _1043_/Y sky130_fd_sc_hd__nor2_1
X_0827_ _0998_/A _1373_/Q VGND VGND VPWR VPWR _0827_/Y sky130_fd_sc_hd__nor2_1
X_0758_ _1420_/Q _1089_/A VGND VGND VPWR VPWR _0758_/Y sky130_fd_sc_hd__nor2_1
XFILLER_28_26 VGND VGND VPWR VPWR sky130_fd_sc_hd__fill_2
XFILLER_29_337 VGND VGND VPWR VPWR sky130_fd_sc_hd__decap_3
X_0689_ _1079_/A _1447_/Q VGND VGND VPWR VPWR _0693_/A sky130_fd_sc_hd__nand2_1
XTAP_TAPCELL_ROW_39_343 VGND VPWR sky130_fd_sc_hd__tapvpwrvgnd_1
XFILLER_37_370 VGND VGND VPWR VPWR sky130_fd_sc_hd__decap_8
XTAP_TAPCELL_ROW_22_232 VGND VPWR sky130_fd_sc_hd__tapvpwrvgnd_1
X_0612_ _0609_/Y _0611_/Y _1193_/B1 VGND VGND VPWR VPWR _1474_/D sky130_fd_sc_hd__a21oi_1
XFILLER_7_241 VGND VGND VPWR VPWR sky130_fd_sc_hd__fill_1
X_1026_ _1026_/A _1310_/Q VGND VGND VPWR VPWR _1026_/Y sky130_fd_sc_hd__nand2_1
XTAP_TAPCELL_ROW_36_324 VGND VPWR sky130_fd_sc_hd__tapvpwrvgnd_1
XFILLER_29_123 VGND VGND VPWR VPWR sky130_fd_sc_hd__decap_12
XTAP_TAPCELL_ROW_33_305 VGND VPWR sky130_fd_sc_hd__tapvpwrvgnd_1
XFILLER_31_365 VGND VGND VPWR VPWR sky130_fd_sc_hd__decap_12
XFILLER_26_126 VGND VGND VPWR VPWR sky130_fd_sc_hd__decap_12
XFILLER_22_376 VGND VGND VPWR VPWR sky130_fd_sc_hd__fill_2
X_1009_ _0998_/B _1053_/A _1199_/B1 _0998_/Y VGND VGND VPWR VPWR _1494_/D sky130_fd_sc_hd__a211oi_2
X_1360_ _1494_/CLK _1408_/D _0634_/B VGND VGND VPWR VPWR _1360_/Q sky130_fd_sc_hd__edfxtp_1
X_1291_ _1466_/CLK _1451_/D _0631_/B VGND VGND VPWR VPWR _1291_/Q sky130_fd_sc_hd__edfxtp_1
X_1489_ _1494_/CLK _1489_/D VGND VGND VPWR VPWR _1489_/Q sky130_fd_sc_hd__dfxtp_1
XFILLER_36_37 VGND VGND VPWR VPWR sky130_fd_sc_hd__fill_2
XFILLER_39_251 VGND VGND VPWR VPWR sky130_fd_sc_hd__fill_1
XFILLER_6_317 VGND VGND VPWR VPWR sky130_fd_sc_hd__fill_2
XFILLER_7_3 VGND VGND VPWR VPWR sky130_fd_sc_hd__decap_4
X_0860_ _0967_/A _1150_/A VGND VGND VPWR VPWR _0944_/B sky130_fd_sc_hd__nand2_1
X_0791_ _0908_/A _1350_/Q _0943_/X _1347_/Q _0790_/Y VGND VGND VPWR VPWR _0807_/A
+ sky130_fd_sc_hd__a221oi_1
XFILLER_9_188 VGND VGND VPWR VPWR sky130_fd_sc_hd__decap_12
X_1343_ clkload4/A _1423_/D _1343_/DE VGND VGND VPWR VPWR _1343_/Q sky130_fd_sc_hd__edfxtp_1
X_1412_ clkload7/A _1412_/D _1423_/DE VGND VGND VPWR VPWR _1412_/Q sky130_fd_sc_hd__edfxtp_1
X_1274_ _1459_/CLK _1450_/D _1277_/DE VGND VGND VPWR VPWR _1274_/Q sky130_fd_sc_hd__edfxtp_1
X_0989_ _0989_/A _0989_/B _0989_/C _1467_/Q VGND VGND VPWR VPWR _0990_/B sky130_fd_sc_hd__nand4_1
Xfanout101 _1409_/D VGND VGND VPWR VPWR _1441_/D sky130_fd_sc_hd__clkdlybuf4s50_1
XTAP_TAPCELL_ROW_6_125 VGND VPWR sky130_fd_sc_hd__tapvpwrvgnd_1
XFILLER_27_221 VGND VGND VPWR VPWR sky130_fd_sc_hd__decap_3
XFILLER_10_110 VGND VGND VPWR VPWR sky130_fd_sc_hd__decap_8
XFILLER_18_298 VGND VGND VPWR VPWR sky130_fd_sc_hd__fill_1
X_0912_ _0912_/A _1470_/Q VGND VGND VPWR VPWR _0913_/B sky130_fd_sc_hd__nand2_1
XTAP_TAPCELL_ROW_28_271 VGND VPWR sky130_fd_sc_hd__tapvpwrvgnd_1
X_0843_ _0902_/A VGND VGND VPWR VPWR _0934_/A sky130_fd_sc_hd__inv_8
X_0774_ _1343_/Q VGND VGND VPWR VPWR _0774_/Y sky130_fd_sc_hd__inv_2
XTAP_TAPCELL_ROW_11_160 VGND VPWR sky130_fd_sc_hd__tapvpwrvgnd_1
X_1326_ clkload9/A _1454_/D _1326_/DE VGND VGND VPWR VPWR _1326_/Q sky130_fd_sc_hd__edfxtp_1
Xclkbuf_leaf_5_clk clkload0/A VGND VGND VPWR VPWR clkload8/A sky130_fd_sc_hd__clkbuf_16
XTAP_TAPCELL_ROW_3_106 VGND VPWR sky130_fd_sc_hd__tapvpwrvgnd_1
X_1257_ _1459_/CLK _1449_/D _1263_/DE VGND VGND VPWR VPWR _1257_/Q sky130_fd_sc_hd__edfxtp_1
X_1188_ _1192_/A _1413_/D VGND VGND VPWR VPWR _1188_/Y sky130_fd_sc_hd__nand2_1
XFILLER_15_279 VGND VGND VPWR VPWR sky130_fd_sc_hd__fill_1
XTAP_TAPCELL_ROW_25_252 VGND VPWR sky130_fd_sc_hd__tapvpwrvgnd_1
XFILLER_2_183 VGND VGND VPWR VPWR sky130_fd_sc_hd__decap_6
XFILLER_31_7 VGND VGND VPWR VPWR sky130_fd_sc_hd__decap_6
X_1111_ _1111_/A _1111_/B _1111_/C VGND VGND VPWR VPWR _1121_/B sky130_fd_sc_hd__nand3_1
X_1042_ _1042_/A _1042_/B VGND VGND VPWR VPWR _1042_/Y sky130_fd_sc_hd__nor2_1
XTAP_TAPCELL_ROW_31_288 VGND VPWR sky130_fd_sc_hd__tapvpwrvgnd_1
X_0826_ _0826_/A _0826_/B VGND VGND VPWR VPWR _0833_/C sky130_fd_sc_hd__nor2_1
X_0757_ _0998_/A _1421_/Q VGND VGND VPWR VPWR _0757_/Y sky130_fd_sc_hd__nor2_1
X_0688_ _0688_/A _1456_/Q VGND VGND VPWR VPWR _0715_/A sky130_fd_sc_hd__nand2_1
X_1309_ clkload8/A _1453_/D _0625_/B VGND VGND VPWR VPWR _1309_/Q sky130_fd_sc_hd__edfxtp_1
XTAP_TAPCELL_ROW_39_344 VGND VPWR sky130_fd_sc_hd__tapvpwrvgnd_1
XFILLER_12_249 VGND VGND VPWR VPWR sky130_fd_sc_hd__decap_3
XTAP_TAPCELL_ROW_22_233 VGND VPWR sky130_fd_sc_hd__tapvpwrvgnd_1
XFILLER_35_308 VGND VGND VPWR VPWR sky130_fd_sc_hd__fill_1
X_0611_ _1198_/A _1410_/D VGND VGND VPWR VPWR _0611_/Y sky130_fd_sc_hd__nand2_1
XFILLER_22_3 VGND VGND VPWR VPWR sky130_fd_sc_hd__fill_1
X_1025_ _1311_/Q VGND VGND VPWR VPWR _1025_/Y sky130_fd_sc_hd__inv_2
XTAP_TAPCELL_ROW_36_325 VGND VPWR sky130_fd_sc_hd__tapvpwrvgnd_1
X_0809_ _1154_/B _1154_/A VGND VGND VPWR VPWR _0998_/B sky130_fd_sc_hd__nor2_1
XFILLER_39_15 VGND VGND VPWR VPWR sky130_fd_sc_hd__fill_2
XFILLER_29_113 VGND VGND VPWR VPWR sky130_fd_sc_hd__decap_4
XFILLER_29_135 VGND VGND VPWR VPWR sky130_fd_sc_hd__decap_8
XFILLER_25_363 VGND VGND VPWR VPWR sky130_fd_sc_hd__decap_12
XFILLER_35_127 VGND VGND VPWR VPWR sky130_fd_sc_hd__fill_2
XTAP_TAPCELL_ROW_33_306 VGND VPWR sky130_fd_sc_hd__tapvpwrvgnd_1
XFILLER_31_377 VGND VGND VPWR VPWR sky130_fd_sc_hd__fill_1
XFILLER_6_85 VGND VGND VPWR VPWR sky130_fd_sc_hd__fill_1
XFILLER_26_138 VGND VGND VPWR VPWR sky130_fd_sc_hd__fill_2
XFILLER_22_333 VGND VGND VPWR VPWR sky130_fd_sc_hd__decap_6
X_1008_ _1063_/A _1291_/Q _1007_/X VGND VGND VPWR VPWR _1015_/C sky130_fd_sc_hd__a21oi_1
XFILLER_9_337 VGND VGND VPWR VPWR sky130_fd_sc_hd__decap_6
XFILLER_0_281 VGND VGND VPWR VPWR sky130_fd_sc_hd__fill_1
X_1290_ _1466_/CLK _1450_/D _0631_/B VGND VGND VPWR VPWR _1290_/Q sky130_fd_sc_hd__edfxtp_1
XFILLER_16_171 VGND VGND VPWR VPWR sky130_fd_sc_hd__fill_1
XFILLER_39_241 VGND VGND VPWR VPWR sky130_fd_sc_hd__fill_2
X_1488_ _1494_/CLK _1488_/D VGND VGND VPWR VPWR _1488_/Q sky130_fd_sc_hd__dfxtp_1
XFILLER_10_336 VGND VGND VPWR VPWR sky130_fd_sc_hd__fill_1
XTAP_TAPCELL_ROW_9_145 VGND VPWR sky130_fd_sc_hd__tapvpwrvgnd_1
X_0790_ _0908_/A _0788_/Y _0789_/Y VGND VGND VPWR VPWR _0790_/Y sky130_fd_sc_hd__o21ai_0
XFILLER_9_167 VGND VGND VPWR VPWR sky130_fd_sc_hd__fill_1
XFILLER_3_86 VGND VGND VPWR VPWR sky130_fd_sc_hd__fill_2
X_1273_ _1459_/CLK _1449_/D _1277_/DE VGND VGND VPWR VPWR _1273_/Q sky130_fd_sc_hd__edfxtp_1
X_1342_ clkload4/A _1422_/D _1343_/DE VGND VGND VPWR VPWR _1342_/Q sky130_fd_sc_hd__edfxtp_1
X_1411_ clkload2/A _1411_/D _1421_/DE VGND VGND VPWR VPWR _1411_/Q sky130_fd_sc_hd__edfxtp_1
X_0988_ _1103_/A _1268_/Q VGND VGND VPWR VPWR _0989_/C sky130_fd_sc_hd__nand2_1
XTAP_TAPCELL_ROW_14_180 VGND VPWR sky130_fd_sc_hd__tapvpwrvgnd_1
Xfanout102 _1473_/Q VGND VGND VPWR VPWR _1409_/D sky130_fd_sc_hd__clkdlybuf4s50_1
XTAP_TAPCELL_ROW_6_126 VGND VPWR sky130_fd_sc_hd__tapvpwrvgnd_1
XFILLER_2_376 VGND VGND VPWR VPWR sky130_fd_sc_hd__fill_2
XFILLER_33_225 VGND VGND VPWR VPWR sky130_fd_sc_hd__decap_4
XTAP_TAPCELL_ROW_28_272 VGND VPWR sky130_fd_sc_hd__tapvpwrvgnd_1
X_0911_ _1099_/A _1219_/Q VGND VGND VPWR VPWR _0912_/A sky130_fd_sc_hd__nand2_1
X_0842_ _0934_/A _1387_/Q _0838_/Y _0841_/Y VGND VGND VPWR VPWR _0845_/B sky130_fd_sc_hd__a211oi_1
X_0773_ _1120_/X _1333_/Q _0767_/Y _0772_/Y VGND VGND VPWR VPWR _0786_/A sky130_fd_sc_hd__a211oi_1
XTAP_TAPCELL_ROW_11_161 VGND VPWR sky130_fd_sc_hd__tapvpwrvgnd_1
X_1325_ clkload8/A _1453_/D _1327_/DE VGND VGND VPWR VPWR _1325_/Q sky130_fd_sc_hd__edfxtp_1
X_1256_ clkload8/A _1448_/D _1263_/DE VGND VGND VPWR VPWR _1256_/Q sky130_fd_sc_hd__edfxtp_1
XTAP_TAPCELL_ROW_3_107 VGND VPWR sky130_fd_sc_hd__tapvpwrvgnd_1
XFILLER_24_203 VGND VGND VPWR VPWR sky130_fd_sc_hd__fill_1
X_1187_ _1191_/A _1187_/B VGND VGND VPWR VPWR _1187_/Y sky130_fd_sc_hd__nand2_1
XFILLER_15_225 VGND VGND VPWR VPWR sky130_fd_sc_hd__decap_4
XTAP_TAPCELL_ROW_25_253 VGND VPWR sky130_fd_sc_hd__tapvpwrvgnd_1
XPHY_EDGE_ROW_29_Left_69 VGND VGND VPWR VPWR sky130_fd_sc_hd__decap_3
XFILLER_38_306 VGND VGND VPWR VPWR sky130_fd_sc_hd__fill_2
XFILLER_38_317 VGND VGND VPWR VPWR sky130_fd_sc_hd__fill_1
X_1110_ _1110_/A _1110_/B VGND VGND VPWR VPWR _1111_/C sky130_fd_sc_hd__nor2_1
X_1041_ _1100_/A _1258_/Q VGND VGND VPWR VPWR _1044_/A sky130_fd_sc_hd__nand2_1
X_0825_ _0825_/A _0825_/B _0825_/C _0825_/D VGND VGND VPWR VPWR _0826_/B sky130_fd_sc_hd__nand4_1
XTAP_TAPCELL_ROW_31_289 VGND VPWR sky130_fd_sc_hd__tapvpwrvgnd_1
X_0756_ _1063_/A _1419_/Q _0755_/Y VGND VGND VPWR VPWR _0762_/C sky130_fd_sc_hd__a21oi_1
X_0687_ _0776_/A _0765_/B VGND VGND VPWR VPWR _0687_/Y sky130_fd_sc_hd__nor2_1
X_1308_ clkload8/A _1452_/D _0625_/B VGND VGND VPWR VPWR _1308_/Q sky130_fd_sc_hd__edfxtp_1
X_1239_ _1469_/CLK _1415_/D _0613_/A VGND VGND VPWR VPWR _1239_/Q sky130_fd_sc_hd__edfxtp_1
XTAP_TAPCELL_ROW_39_345 VGND VPWR sky130_fd_sc_hd__tapvpwrvgnd_1
XTAP_TAPCELL_ROW_22_234 VGND VPWR sky130_fd_sc_hd__tapvpwrvgnd_1
XFILLER_34_82 VGND VGND VPWR VPWR sky130_fd_sc_hd__fill_2
X_0610_ _0610_/A VGND VGND VPWR VPWR _0787_/B sky130_fd_sc_hd__inv_1
XFILLER_15_3 VGND VGND VPWR VPWR sky130_fd_sc_hd__decap_12
X_1024_ _1120_/X _1301_/Q _1017_/Y _1023_/Y VGND VGND VPWR VPWR _1037_/A sky130_fd_sc_hd__a211oi_1
XTAP_TAPCELL_ROW_36_326 VGND VPWR sky130_fd_sc_hd__tapvpwrvgnd_1
XFILLER_34_320 VGND VGND VPWR VPWR sky130_fd_sc_hd__fill_1
X_0808_ _1375_/Q VGND VGND VPWR VPWR _0808_/Y sky130_fd_sc_hd__inv_2
XFILLER_39_27 VGND VGND VPWR VPWR sky130_fd_sc_hd__fill_1
X_0739_ _1423_/Q VGND VGND VPWR VPWR _0739_/Y sky130_fd_sc_hd__inv_2
XFILLER_25_331 VGND VGND VPWR VPWR sky130_fd_sc_hd__fill_2
XFILLER_25_375 VGND VGND VPWR VPWR sky130_fd_sc_hd__decap_3
XFILLER_29_169 VGND VGND VPWR VPWR sky130_fd_sc_hd__decap_8
XFILLER_20_73 VGND VGND VPWR VPWR sky130_fd_sc_hd__decap_8
XFILLER_16_320 VGND VGND VPWR VPWR sky130_fd_sc_hd__decap_12
XFILLER_16_353 VGND VGND VPWR VPWR sky130_fd_sc_hd__fill_2
X_1007_ _1100_/A _1290_/Q _0943_/X _1283_/Q VGND VGND VPWR VPWR _1007_/X sky130_fd_sc_hd__a22o_1
XPHY_EDGE_ROW_16_Left_56 VGND VGND VPWR VPWR sky130_fd_sc_hd__decap_3
XFILLER_15_40 VGND VGND VPWR VPWR sky130_fd_sc_hd__decap_4
XFILLER_31_131 VGND VGND VPWR VPWR sky130_fd_sc_hd__decap_12
XFILLER_39_264 VGND VGND VPWR VPWR sky130_fd_sc_hd__decap_12
X_1487_ clkload3/A _1487_/D VGND VGND VPWR VPWR _1487_/Q sky130_fd_sc_hd__dfxtp_1
XFILLER_22_197 VGND VGND VPWR VPWR sky130_fd_sc_hd__decap_4
XTAP_TAPCELL_ROW_9_146 VGND VPWR sky130_fd_sc_hd__tapvpwrvgnd_1
XFILLER_9_113 VGND VGND VPWR VPWR sky130_fd_sc_hd__decap_4
XFILLER_9_102 VGND VGND VPWR VPWR sky130_fd_sc_hd__decap_3
X_1410_ clkload7/A _1410_/D _1423_/DE VGND VGND VPWR VPWR _1410_/Q sky130_fd_sc_hd__edfxtp_1
X_1272_ _1459_/CLK _1448_/D _1277_/DE VGND VGND VPWR VPWR _1272_/Q sky130_fd_sc_hd__edfxtp_1
X_1341_ clkload8/A _1421_/D _0638_/B VGND VGND VPWR VPWR _1341_/Q sky130_fd_sc_hd__edfxtp_1
X_0987_ _1082_/A VGND VGND VPWR VPWR _1053_/A sky130_fd_sc_hd__buf_8
XTAP_TAPCELL_ROW_14_181 VGND VPWR sky130_fd_sc_hd__tapvpwrvgnd_1
Xfanout103 _1472_/Q VGND VGND VPWR VPWR _1408_/D sky130_fd_sc_hd__clkdlybuf4s50_1
XTAP_TAPCELL_ROW_6_127 VGND VPWR sky130_fd_sc_hd__tapvpwrvgnd_1
XFILLER_18_212 VGND VGND VPWR VPWR sky130_fd_sc_hd__decap_6
XFILLER_18_289 VGND VGND VPWR VPWR sky130_fd_sc_hd__fill_1
XFILLER_37_71 VGND VGND VPWR VPWR sky130_fd_sc_hd__fill_1
XTAP_TAPCELL_ROW_28_273 VGND VPWR sky130_fd_sc_hd__tapvpwrvgnd_1
XPHY_EDGE_ROW_16_Right_16 VGND VGND VPWR VPWR sky130_fd_sc_hd__decap_3
X_0910_ _1223_/Q _0910_/B VGND VGND VPWR VPWR _0913_/A sky130_fd_sc_hd__nor2_1
X_0841_ _0841_/A _0841_/B VGND VGND VPWR VPWR _0841_/Y sky130_fd_sc_hd__nand2_1
X_0772_ _0772_/A _0772_/B _0772_/C _0772_/D VGND VGND VPWR VPWR _0772_/Y sky130_fd_sc_hd__nand4_1
XTAP_TAPCELL_ROW_11_162 VGND VPWR sky130_fd_sc_hd__tapvpwrvgnd_1
XPHY_EDGE_ROW_25_Right_25 VGND VGND VPWR VPWR sky130_fd_sc_hd__decap_3
X_1324_ clkload8/A _1452_/D _1327_/DE VGND VGND VPWR VPWR _1324_/Q sky130_fd_sc_hd__edfxtp_1
X_1255_ _1468_/CLK _1447_/D _1259_/DE VGND VGND VPWR VPWR _1255_/Q sky130_fd_sc_hd__edfxtp_1
X_1186_ _1184_/Y _1185_/Y _0642_/A VGND VGND VPWR VPWR _1482_/D sky130_fd_sc_hd__a21oi_1
XTAP_TAPCELL_ROW_3_108 VGND VPWR sky130_fd_sc_hd__tapvpwrvgnd_1
XPHY_EDGE_ROW_34_Right_34 VGND VGND VPWR VPWR sky130_fd_sc_hd__decap_3
XPHY_EDGE_ROW_4_Left_44 VGND VGND VPWR VPWR sky130_fd_sc_hd__decap_3
XFILLER_23_281 VGND VGND VPWR VPWR sky130_fd_sc_hd__decap_3
XTAP_TAPCELL_ROW_25_254 VGND VPWR sky130_fd_sc_hd__tapvpwrvgnd_1
XFILLER_2_141 VGND VGND VPWR VPWR sky130_fd_sc_hd__fill_1
XFILLER_0_33 VGND VGND VPWR VPWR sky130_fd_sc_hd__fill_1
X_1040_ _1155_/A VGND VGND VPWR VPWR _1129_/B sky130_fd_sc_hd__inv_1
XFILLER_0_55 VGND VGND VPWR VPWR sky130_fd_sc_hd__fill_1
X_0824_ _0908_/A _1366_/Q VGND VGND VPWR VPWR _0825_/D sky130_fd_sc_hd__nand2_1
X_0755_ _0755_/A _0755_/B VGND VGND VPWR VPWR _0755_/Y sky130_fd_sc_hd__nand2_1
X_0686_ _1120_/A _1445_/Q VGND VGND VPWR VPWR _0688_/A sky130_fd_sc_hd__nand2_1
X_1307_ _1466_/CLK _1451_/D _1311_/DE VGND VGND VPWR VPWR _1307_/Q sky130_fd_sc_hd__edfxtp_1
X_1238_ _1469_/CLK _1446_/D _0613_/A VGND VGND VPWR VPWR _1238_/Q sky130_fd_sc_hd__edfxtp_1
X_1169_ _1192_/A _1423_/D VGND VGND VPWR VPWR _1169_/Y sky130_fd_sc_hd__nand2_1
XTAP_TAPCELL_ROW_39_346 VGND VPWR sky130_fd_sc_hd__tapvpwrvgnd_1
XTAP_TAPCELL_ROW_22_235 VGND VPWR sky130_fd_sc_hd__tapvpwrvgnd_1
XFILLER_19_340 VGND VGND VPWR VPWR sky130_fd_sc_hd__decap_8
XFILLER_19_351 VGND VGND VPWR VPWR sky130_fd_sc_hd__fill_1
XFILLER_38_137 VGND VGND VPWR VPWR sky130_fd_sc_hd__decap_3
X_1023_ _1023_/A _1023_/B _1023_/C _1023_/D VGND VGND VPWR VPWR _1023_/Y sky130_fd_sc_hd__nand4_1
XFILLER_34_365 VGND VGND VPWR VPWR sky130_fd_sc_hd__decap_12
X_0807_ _0807_/A _0807_/B _0807_/C _0807_/D VGND VGND VPWR VPWR _1139_/B sky130_fd_sc_hd__nand4_2
X_0738_ _0738_/A _0738_/B _0738_/C _0738_/D VGND VGND VPWR VPWR _1143_/B sky130_fd_sc_hd__nand4_1
X_0669_ _0998_/A VGND VGND VPWR VPWR _1089_/A sky130_fd_sc_hd__inv_6
XPHY_EDGE_ROW_2_Right_2 VGND VGND VPWR VPWR sky130_fd_sc_hd__decap_3
XFILLER_25_310 VGND VGND VPWR VPWR sky130_fd_sc_hd__fill_1
XFILLER_4_225 VGND VGND VPWR VPWR sky130_fd_sc_hd__decap_6
XFILLER_16_332 VGND VGND VPWR VPWR sky130_fd_sc_hd__decap_3
XFILLER_31_335 VGND VGND VPWR VPWR sky130_fd_sc_hd__fill_1
X_1006_ _1006_/A _1006_/B VGND VGND VPWR VPWR _1015_/B sky130_fd_sc_hd__nor2_1
XPHY_EDGE_ROW_33_Left_73 VGND VGND VPWR VPWR sky130_fd_sc_hd__decap_3
XFILLER_0_250 VGND VGND VPWR VPWR sky130_fd_sc_hd__fill_2
XTAP_TAPCELL_ROW_2_99 VGND VPWR sky130_fd_sc_hd__tapvpwrvgnd_1
XFILLER_31_110 VGND VGND VPWR VPWR sky130_fd_sc_hd__fill_2
XFILLER_31_143 VGND VGND VPWR VPWR sky130_fd_sc_hd__fill_1
XFILLER_39_276 VGND VGND VPWR VPWR sky130_fd_sc_hd__decap_4
X_1486_ clkload3/A _1486_/D VGND VGND VPWR VPWR _1486_/Q sky130_fd_sc_hd__dfxtp_1
XTAP_TAPCELL_ROW_9_147 VGND VPWR sky130_fd_sc_hd__tapvpwrvgnd_1
XFILLER_13_110 VGND VGND VPWR VPWR sky130_fd_sc_hd__fill_2
XFILLER_9_136 VGND VGND VPWR VPWR sky130_fd_sc_hd__decap_6
X_1340_ clkload8/A _1420_/D _0638_/B VGND VGND VPWR VPWR _1340_/Q sky130_fd_sc_hd__edfxtp_1
XFILLER_5_375 VGND VGND VPWR VPWR sky130_fd_sc_hd__decap_3
X_1271_ _1459_/CLK _1447_/D _1277_/DE VGND VGND VPWR VPWR _1271_/Q sky130_fd_sc_hd__edfxtp_1
XFILLER_36_257 VGND VGND VPWR VPWR sky130_fd_sc_hd__fill_1
Xclkbuf_leaf_8_clk clkload0/A VGND VGND VPWR VPWR _1468_/CLK sky130_fd_sc_hd__clkbuf_16
X_0986_ _1107_/B _1278_/Q VGND VGND VPWR VPWR _0989_/B sky130_fd_sc_hd__nand2_1
XTAP_TAPCELL_ROW_14_182 VGND VPWR sky130_fd_sc_hd__tapvpwrvgnd_1
X_1469_ _1469_/CLK _1469_/D VGND VGND VPWR VPWR _1469_/Q sky130_fd_sc_hd__dfxtp_1
Xfanout104 _1472_/Q VGND VGND VPWR VPWR _1440_/D sky130_fd_sc_hd__clkdlybuf4s50_1
XTAP_TAPCELL_ROW_6_128 VGND VPWR sky130_fd_sc_hd__tapvpwrvgnd_1
XFILLER_12_53 VGND VGND VPWR VPWR sky130_fd_sc_hd__decap_6
XFILLER_2_301 VGND VGND VPWR VPWR sky130_fd_sc_hd__fill_1
XFILLER_6_139 VGND VGND VPWR VPWR sky130_fd_sc_hd__fill_1
XFILLER_5_3 VGND VGND VPWR VPWR sky130_fd_sc_hd__decap_8
XFILLER_18_246 VGND VGND VPWR VPWR sky130_fd_sc_hd__decap_6
XTAP_TAPCELL_ROW_28_274 VGND VPWR sky130_fd_sc_hd__tapvpwrvgnd_1
X_0840_ _1046_/A _1384_/Q VGND VGND VPWR VPWR _0841_/B sky130_fd_sc_hd__nand2_1
X_0771_ _0908_/A _1334_/Q VGND VGND VPWR VPWR _0772_/D sky130_fd_sc_hd__nand2_1
XTAP_TAPCELL_ROW_11_163 VGND VPWR sky130_fd_sc_hd__tapvpwrvgnd_1
XFILLER_38_3 VGND VGND VPWR VPWR sky130_fd_sc_hd__decap_8
X_1323_ clkload9/A _1451_/D _1327_/DE VGND VGND VPWR VPWR _1323_/Q sky130_fd_sc_hd__edfxtp_1
XFILLER_5_161 VGND VGND VPWR VPWR sky130_fd_sc_hd__fill_2
X_1254_ _1468_/CLK _1446_/D _1259_/DE VGND VGND VPWR VPWR _1254_/Q sky130_fd_sc_hd__edfxtp_1
X_1185_ _1192_/A _1418_/D VGND VGND VPWR VPWR _1185_/Y sky130_fd_sc_hd__nand2_1
XTAP_TAPCELL_ROW_3_109 VGND VPWR sky130_fd_sc_hd__tapvpwrvgnd_1
XPHY_EDGE_ROW_20_Left_60 VGND VGND VPWR VPWR sky130_fd_sc_hd__decap_3
X_0969_ _1157_/B VGND VGND VPWR VPWR _1130_/A sky130_fd_sc_hd__inv_2
XFILLER_15_216 VGND VGND VPWR VPWR sky130_fd_sc_hd__decap_8
XFILLER_23_85 VGND VGND VPWR VPWR sky130_fd_sc_hd__decap_3
X_0823_ _1049_/A _1360_/Q VGND VGND VPWR VPWR _0825_/C sky130_fd_sc_hd__nand2_1
X_0754_ _0754_/A _0787_/B VGND VGND VPWR VPWR _0754_/Y sky130_fd_sc_hd__nor2_1
X_0685_ _0685_/A _0685_/B _0685_/C _0685_/D VGND VGND VPWR VPWR _1145_/A sky130_fd_sc_hd__nor4_4
X_1306_ _1466_/CLK _1450_/D _1311_/DE VGND VGND VPWR VPWR _1306_/Q sky130_fd_sc_hd__edfxtp_1
X_1237_ _1469_/CLK _1445_/D _0613_/A VGND VGND VPWR VPWR _1237_/Q sky130_fd_sc_hd__edfxtp_1
X_1168_ _1191_/A _1417_/D VGND VGND VPWR VPWR _1168_/Y sky130_fd_sc_hd__nand2_1
X_1099_ _1099_/A _1235_/Q VGND VGND VPWR VPWR _1101_/A sky130_fd_sc_hd__nand2_2
XTAP_TAPCELL_ROW_39_347 VGND VPWR sky130_fd_sc_hd__tapvpwrvgnd_1
XFILLER_18_85 VGND VGND VPWR VPWR sky130_fd_sc_hd__fill_2
XFILLER_34_377 VGND VGND VPWR VPWR sky130_fd_sc_hd__fill_1
X_1022_ _1083_/A _1302_/Q VGND VGND VPWR VPWR _1023_/D sky130_fd_sc_hd__nand2_1
X_0806_ _1053_/A _1345_/Q _0805_/X VGND VGND VPWR VPWR _0807_/D sky130_fd_sc_hd__a21oi_1
X_0737_ _1070_/B _1405_/Q _0736_/X VGND VGND VPWR VPWR _0738_/D sky130_fd_sc_hd__a21oi_1
X_0668_ _0668_/A VGND VGND VPWR VPWR _0685_/C sky130_fd_sc_hd__inv_2
X_0599_ _1189_/Y _0709_/A VGND VGND VPWR VPWR _0610_/A sky130_fd_sc_hd__nor2_1
XFILLER_29_40 VGND VGND VPWR VPWR sky130_fd_sc_hd__decap_4
XFILLER_4_259 VGND VGND VPWR VPWR sky130_fd_sc_hd__decap_4
XFILLER_16_377 VGND VGND VPWR VPWR sky130_fd_sc_hd__fill_1
XFILLER_20_3 VGND VGND VPWR VPWR sky130_fd_sc_hd__decap_12
XFILLER_34_141 VGND VGND VPWR VPWR sky130_fd_sc_hd__fill_1
X_1005_ _1005_/A _1005_/B _1005_/C _1005_/D VGND VGND VPWR VPWR _1006_/B sky130_fd_sc_hd__nand4_1
XFILLER_17_119 VGND VGND VPWR VPWR sky130_fd_sc_hd__fill_1
XFILLER_25_163 VGND VGND VPWR VPWR sky130_fd_sc_hd__fill_2
XFILLER_0_273 VGND VGND VPWR VPWR sky130_fd_sc_hd__fill_2
X_1485_ _1494_/CLK _1485_/D VGND VGND VPWR VPWR _1485_/Q sky130_fd_sc_hd__dfxtp_1
.ends
